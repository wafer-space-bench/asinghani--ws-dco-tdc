* COARSE delay-line TDC: delta_t=15000ps, 90 inv/tap, 8 taps
.param fnoicor=0
.param sw_stat_global=0
.param sw_stat_mismatch=0
.param mc_skew=3
.param res_mc_skew=3
.param cap_mc_skew=3
.include /home/anish/wafer_space_docker_based_starter_kit/pdk/gf180mcuD/libs.tech/ngspice/design.ngspice
.include /home/anish/wafer_space_docker_based_starter_kit/spice_sim/sm141064_typical.spice
.include /home/anish/wafer_space_docker_based_starter_kit/spice_sim/smbb000149_typical.spice
.include pdk/gf180mcuD/libs.ref/gf180mcu_fd_sc_mcu7t5v0/spice/gf180mcu_fd_sc_mcu7t5v0.spice

VDD_net VDD 0 5.0
VSS_net VSS 0 0

Vrn RN 0 PULSE(0 5 5n 0.1n 0.1n 500n 1000n)
Vstart START_IN 0 PULSE(0 5 10n 0.1n 0.1n 500n 1000n)
Vstop STOP_IN 0 PULSE(0 5 25.0n 0.1n 0.1n 500n 1000n)

Xs_0_0 START_IN coarse_s0_0 VDD VDD VSS VSS gf180mcu_fd_sc_mcu7t5v0__inv_1
Xs_0_1 coarse_s0_0 coarse_s0_1 VDD VDD VSS VSS gf180mcu_fd_sc_mcu7t5v0__inv_1
Xs_0_2 coarse_s0_1 coarse_s0_2 VDD VDD VSS VSS gf180mcu_fd_sc_mcu7t5v0__inv_1
Xs_0_3 coarse_s0_2 coarse_s0_3 VDD VDD VSS VSS gf180mcu_fd_sc_mcu7t5v0__inv_1
Xs_0_4 coarse_s0_3 coarse_s0_4 VDD VDD VSS VSS gf180mcu_fd_sc_mcu7t5v0__inv_1
Xs_0_5 coarse_s0_4 coarse_s0_5 VDD VDD VSS VSS gf180mcu_fd_sc_mcu7t5v0__inv_1
Xs_0_6 coarse_s0_5 coarse_s0_6 VDD VDD VSS VSS gf180mcu_fd_sc_mcu7t5v0__inv_1
Xs_0_7 coarse_s0_6 coarse_s0_7 VDD VDD VSS VSS gf180mcu_fd_sc_mcu7t5v0__inv_1
Xs_0_8 coarse_s0_7 coarse_s0_8 VDD VDD VSS VSS gf180mcu_fd_sc_mcu7t5v0__inv_1
Xs_0_9 coarse_s0_8 coarse_s0_9 VDD VDD VSS VSS gf180mcu_fd_sc_mcu7t5v0__inv_1
Xs_0_10 coarse_s0_9 coarse_s0_10 VDD VDD VSS VSS gf180mcu_fd_sc_mcu7t5v0__inv_1
Xs_0_11 coarse_s0_10 coarse_s0_11 VDD VDD VSS VSS gf180mcu_fd_sc_mcu7t5v0__inv_1
Xs_0_12 coarse_s0_11 coarse_s0_12 VDD VDD VSS VSS gf180mcu_fd_sc_mcu7t5v0__inv_1
Xs_0_13 coarse_s0_12 coarse_s0_13 VDD VDD VSS VSS gf180mcu_fd_sc_mcu7t5v0__inv_1
Xs_0_14 coarse_s0_13 coarse_s0_14 VDD VDD VSS VSS gf180mcu_fd_sc_mcu7t5v0__inv_1
Xs_0_15 coarse_s0_14 coarse_s0_15 VDD VDD VSS VSS gf180mcu_fd_sc_mcu7t5v0__inv_1
Xs_0_16 coarse_s0_15 coarse_s0_16 VDD VDD VSS VSS gf180mcu_fd_sc_mcu7t5v0__inv_1
Xs_0_17 coarse_s0_16 coarse_s0_17 VDD VDD VSS VSS gf180mcu_fd_sc_mcu7t5v0__inv_1
Xs_0_18 coarse_s0_17 coarse_s0_18 VDD VDD VSS VSS gf180mcu_fd_sc_mcu7t5v0__inv_1
Xs_0_19 coarse_s0_18 coarse_s0_19 VDD VDD VSS VSS gf180mcu_fd_sc_mcu7t5v0__inv_1
Xs_0_20 coarse_s0_19 coarse_s0_20 VDD VDD VSS VSS gf180mcu_fd_sc_mcu7t5v0__inv_1
Xs_0_21 coarse_s0_20 coarse_s0_21 VDD VDD VSS VSS gf180mcu_fd_sc_mcu7t5v0__inv_1
Xs_0_22 coarse_s0_21 coarse_s0_22 VDD VDD VSS VSS gf180mcu_fd_sc_mcu7t5v0__inv_1
Xs_0_23 coarse_s0_22 coarse_s0_23 VDD VDD VSS VSS gf180mcu_fd_sc_mcu7t5v0__inv_1
Xs_0_24 coarse_s0_23 coarse_s0_24 VDD VDD VSS VSS gf180mcu_fd_sc_mcu7t5v0__inv_1
Xs_0_25 coarse_s0_24 coarse_s0_25 VDD VDD VSS VSS gf180mcu_fd_sc_mcu7t5v0__inv_1
Xs_0_26 coarse_s0_25 coarse_s0_26 VDD VDD VSS VSS gf180mcu_fd_sc_mcu7t5v0__inv_1
Xs_0_27 coarse_s0_26 coarse_s0_27 VDD VDD VSS VSS gf180mcu_fd_sc_mcu7t5v0__inv_1
Xs_0_28 coarse_s0_27 coarse_s0_28 VDD VDD VSS VSS gf180mcu_fd_sc_mcu7t5v0__inv_1
Xs_0_29 coarse_s0_28 coarse_s0_29 VDD VDD VSS VSS gf180mcu_fd_sc_mcu7t5v0__inv_1
Xs_0_30 coarse_s0_29 coarse_s0_30 VDD VDD VSS VSS gf180mcu_fd_sc_mcu7t5v0__inv_1
Xs_0_31 coarse_s0_30 coarse_s0_31 VDD VDD VSS VSS gf180mcu_fd_sc_mcu7t5v0__inv_1
Xs_0_32 coarse_s0_31 coarse_s0_32 VDD VDD VSS VSS gf180mcu_fd_sc_mcu7t5v0__inv_1
Xs_0_33 coarse_s0_32 coarse_s0_33 VDD VDD VSS VSS gf180mcu_fd_sc_mcu7t5v0__inv_1
Xs_0_34 coarse_s0_33 coarse_s0_34 VDD VDD VSS VSS gf180mcu_fd_sc_mcu7t5v0__inv_1
Xs_0_35 coarse_s0_34 coarse_s0_35 VDD VDD VSS VSS gf180mcu_fd_sc_mcu7t5v0__inv_1
Xs_0_36 coarse_s0_35 coarse_s0_36 VDD VDD VSS VSS gf180mcu_fd_sc_mcu7t5v0__inv_1
Xs_0_37 coarse_s0_36 coarse_s0_37 VDD VDD VSS VSS gf180mcu_fd_sc_mcu7t5v0__inv_1
Xs_0_38 coarse_s0_37 coarse_s0_38 VDD VDD VSS VSS gf180mcu_fd_sc_mcu7t5v0__inv_1
Xs_0_39 coarse_s0_38 coarse_s0_39 VDD VDD VSS VSS gf180mcu_fd_sc_mcu7t5v0__inv_1
Xs_0_40 coarse_s0_39 coarse_s0_40 VDD VDD VSS VSS gf180mcu_fd_sc_mcu7t5v0__inv_1
Xs_0_41 coarse_s0_40 coarse_s0_41 VDD VDD VSS VSS gf180mcu_fd_sc_mcu7t5v0__inv_1
Xs_0_42 coarse_s0_41 coarse_s0_42 VDD VDD VSS VSS gf180mcu_fd_sc_mcu7t5v0__inv_1
Xs_0_43 coarse_s0_42 coarse_s0_43 VDD VDD VSS VSS gf180mcu_fd_sc_mcu7t5v0__inv_1
Xs_0_44 coarse_s0_43 coarse_s0_44 VDD VDD VSS VSS gf180mcu_fd_sc_mcu7t5v0__inv_1
Xs_0_45 coarse_s0_44 coarse_s0_45 VDD VDD VSS VSS gf180mcu_fd_sc_mcu7t5v0__inv_1
Xs_0_46 coarse_s0_45 coarse_s0_46 VDD VDD VSS VSS gf180mcu_fd_sc_mcu7t5v0__inv_1
Xs_0_47 coarse_s0_46 coarse_s0_47 VDD VDD VSS VSS gf180mcu_fd_sc_mcu7t5v0__inv_1
Xs_0_48 coarse_s0_47 coarse_s0_48 VDD VDD VSS VSS gf180mcu_fd_sc_mcu7t5v0__inv_1
Xs_0_49 coarse_s0_48 coarse_s0_49 VDD VDD VSS VSS gf180mcu_fd_sc_mcu7t5v0__inv_1
Xs_0_50 coarse_s0_49 coarse_s0_50 VDD VDD VSS VSS gf180mcu_fd_sc_mcu7t5v0__inv_1
Xs_0_51 coarse_s0_50 coarse_s0_51 VDD VDD VSS VSS gf180mcu_fd_sc_mcu7t5v0__inv_1
Xs_0_52 coarse_s0_51 coarse_s0_52 VDD VDD VSS VSS gf180mcu_fd_sc_mcu7t5v0__inv_1
Xs_0_53 coarse_s0_52 coarse_s0_53 VDD VDD VSS VSS gf180mcu_fd_sc_mcu7t5v0__inv_1
Xs_0_54 coarse_s0_53 coarse_s0_54 VDD VDD VSS VSS gf180mcu_fd_sc_mcu7t5v0__inv_1
Xs_0_55 coarse_s0_54 coarse_s0_55 VDD VDD VSS VSS gf180mcu_fd_sc_mcu7t5v0__inv_1
Xs_0_56 coarse_s0_55 coarse_s0_56 VDD VDD VSS VSS gf180mcu_fd_sc_mcu7t5v0__inv_1
Xs_0_57 coarse_s0_56 coarse_s0_57 VDD VDD VSS VSS gf180mcu_fd_sc_mcu7t5v0__inv_1
Xs_0_58 coarse_s0_57 coarse_s0_58 VDD VDD VSS VSS gf180mcu_fd_sc_mcu7t5v0__inv_1
Xs_0_59 coarse_s0_58 coarse_s0_59 VDD VDD VSS VSS gf180mcu_fd_sc_mcu7t5v0__inv_1
Xs_0_60 coarse_s0_59 coarse_s0_60 VDD VDD VSS VSS gf180mcu_fd_sc_mcu7t5v0__inv_1
Xs_0_61 coarse_s0_60 coarse_s0_61 VDD VDD VSS VSS gf180mcu_fd_sc_mcu7t5v0__inv_1
Xs_0_62 coarse_s0_61 coarse_s0_62 VDD VDD VSS VSS gf180mcu_fd_sc_mcu7t5v0__inv_1
Xs_0_63 coarse_s0_62 coarse_s0_63 VDD VDD VSS VSS gf180mcu_fd_sc_mcu7t5v0__inv_1
Xs_0_64 coarse_s0_63 coarse_s0_64 VDD VDD VSS VSS gf180mcu_fd_sc_mcu7t5v0__inv_1
Xs_0_65 coarse_s0_64 coarse_s0_65 VDD VDD VSS VSS gf180mcu_fd_sc_mcu7t5v0__inv_1
Xs_0_66 coarse_s0_65 coarse_s0_66 VDD VDD VSS VSS gf180mcu_fd_sc_mcu7t5v0__inv_1
Xs_0_67 coarse_s0_66 coarse_s0_67 VDD VDD VSS VSS gf180mcu_fd_sc_mcu7t5v0__inv_1
Xs_0_68 coarse_s0_67 coarse_s0_68 VDD VDD VSS VSS gf180mcu_fd_sc_mcu7t5v0__inv_1
Xs_0_69 coarse_s0_68 coarse_s0_69 VDD VDD VSS VSS gf180mcu_fd_sc_mcu7t5v0__inv_1
Xs_0_70 coarse_s0_69 coarse_s0_70 VDD VDD VSS VSS gf180mcu_fd_sc_mcu7t5v0__inv_1
Xs_0_71 coarse_s0_70 coarse_s0_71 VDD VDD VSS VSS gf180mcu_fd_sc_mcu7t5v0__inv_1
Xs_0_72 coarse_s0_71 coarse_s0_72 VDD VDD VSS VSS gf180mcu_fd_sc_mcu7t5v0__inv_1
Xs_0_73 coarse_s0_72 coarse_s0_73 VDD VDD VSS VSS gf180mcu_fd_sc_mcu7t5v0__inv_1
Xs_0_74 coarse_s0_73 coarse_s0_74 VDD VDD VSS VSS gf180mcu_fd_sc_mcu7t5v0__inv_1
Xs_0_75 coarse_s0_74 coarse_s0_75 VDD VDD VSS VSS gf180mcu_fd_sc_mcu7t5v0__inv_1
Xs_0_76 coarse_s0_75 coarse_s0_76 VDD VDD VSS VSS gf180mcu_fd_sc_mcu7t5v0__inv_1
Xs_0_77 coarse_s0_76 coarse_s0_77 VDD VDD VSS VSS gf180mcu_fd_sc_mcu7t5v0__inv_1
Xs_0_78 coarse_s0_77 coarse_s0_78 VDD VDD VSS VSS gf180mcu_fd_sc_mcu7t5v0__inv_1
Xs_0_79 coarse_s0_78 coarse_s0_79 VDD VDD VSS VSS gf180mcu_fd_sc_mcu7t5v0__inv_1
Xs_0_80 coarse_s0_79 coarse_s0_80 VDD VDD VSS VSS gf180mcu_fd_sc_mcu7t5v0__inv_1
Xs_0_81 coarse_s0_80 coarse_s0_81 VDD VDD VSS VSS gf180mcu_fd_sc_mcu7t5v0__inv_1
Xs_0_82 coarse_s0_81 coarse_s0_82 VDD VDD VSS VSS gf180mcu_fd_sc_mcu7t5v0__inv_1
Xs_0_83 coarse_s0_82 coarse_s0_83 VDD VDD VSS VSS gf180mcu_fd_sc_mcu7t5v0__inv_1
Xs_0_84 coarse_s0_83 coarse_s0_84 VDD VDD VSS VSS gf180mcu_fd_sc_mcu7t5v0__inv_1
Xs_0_85 coarse_s0_84 coarse_s0_85 VDD VDD VSS VSS gf180mcu_fd_sc_mcu7t5v0__inv_1
Xs_0_86 coarse_s0_85 coarse_s0_86 VDD VDD VSS VSS gf180mcu_fd_sc_mcu7t5v0__inv_1
Xs_0_87 coarse_s0_86 coarse_s0_87 VDD VDD VSS VSS gf180mcu_fd_sc_mcu7t5v0__inv_1
Xs_0_88 coarse_s0_87 coarse_s0_88 VDD VDD VSS VSS gf180mcu_fd_sc_mcu7t5v0__inv_1
Xs_0_89 coarse_s0_88 coarse_tap_s0 VDD VDD VSS VSS gf180mcu_fd_sc_mcu7t5v0__inv_1
Xs_1_0 coarse_tap_s0 coarse_s1_0 VDD VDD VSS VSS gf180mcu_fd_sc_mcu7t5v0__inv_1
Xs_1_1 coarse_s1_0 coarse_s1_1 VDD VDD VSS VSS gf180mcu_fd_sc_mcu7t5v0__inv_1
Xs_1_2 coarse_s1_1 coarse_s1_2 VDD VDD VSS VSS gf180mcu_fd_sc_mcu7t5v0__inv_1
Xs_1_3 coarse_s1_2 coarse_s1_3 VDD VDD VSS VSS gf180mcu_fd_sc_mcu7t5v0__inv_1
Xs_1_4 coarse_s1_3 coarse_s1_4 VDD VDD VSS VSS gf180mcu_fd_sc_mcu7t5v0__inv_1
Xs_1_5 coarse_s1_4 coarse_s1_5 VDD VDD VSS VSS gf180mcu_fd_sc_mcu7t5v0__inv_1
Xs_1_6 coarse_s1_5 coarse_s1_6 VDD VDD VSS VSS gf180mcu_fd_sc_mcu7t5v0__inv_1
Xs_1_7 coarse_s1_6 coarse_s1_7 VDD VDD VSS VSS gf180mcu_fd_sc_mcu7t5v0__inv_1
Xs_1_8 coarse_s1_7 coarse_s1_8 VDD VDD VSS VSS gf180mcu_fd_sc_mcu7t5v0__inv_1
Xs_1_9 coarse_s1_8 coarse_s1_9 VDD VDD VSS VSS gf180mcu_fd_sc_mcu7t5v0__inv_1
Xs_1_10 coarse_s1_9 coarse_s1_10 VDD VDD VSS VSS gf180mcu_fd_sc_mcu7t5v0__inv_1
Xs_1_11 coarse_s1_10 coarse_s1_11 VDD VDD VSS VSS gf180mcu_fd_sc_mcu7t5v0__inv_1
Xs_1_12 coarse_s1_11 coarse_s1_12 VDD VDD VSS VSS gf180mcu_fd_sc_mcu7t5v0__inv_1
Xs_1_13 coarse_s1_12 coarse_s1_13 VDD VDD VSS VSS gf180mcu_fd_sc_mcu7t5v0__inv_1
Xs_1_14 coarse_s1_13 coarse_s1_14 VDD VDD VSS VSS gf180mcu_fd_sc_mcu7t5v0__inv_1
Xs_1_15 coarse_s1_14 coarse_s1_15 VDD VDD VSS VSS gf180mcu_fd_sc_mcu7t5v0__inv_1
Xs_1_16 coarse_s1_15 coarse_s1_16 VDD VDD VSS VSS gf180mcu_fd_sc_mcu7t5v0__inv_1
Xs_1_17 coarse_s1_16 coarse_s1_17 VDD VDD VSS VSS gf180mcu_fd_sc_mcu7t5v0__inv_1
Xs_1_18 coarse_s1_17 coarse_s1_18 VDD VDD VSS VSS gf180mcu_fd_sc_mcu7t5v0__inv_1
Xs_1_19 coarse_s1_18 coarse_s1_19 VDD VDD VSS VSS gf180mcu_fd_sc_mcu7t5v0__inv_1
Xs_1_20 coarse_s1_19 coarse_s1_20 VDD VDD VSS VSS gf180mcu_fd_sc_mcu7t5v0__inv_1
Xs_1_21 coarse_s1_20 coarse_s1_21 VDD VDD VSS VSS gf180mcu_fd_sc_mcu7t5v0__inv_1
Xs_1_22 coarse_s1_21 coarse_s1_22 VDD VDD VSS VSS gf180mcu_fd_sc_mcu7t5v0__inv_1
Xs_1_23 coarse_s1_22 coarse_s1_23 VDD VDD VSS VSS gf180mcu_fd_sc_mcu7t5v0__inv_1
Xs_1_24 coarse_s1_23 coarse_s1_24 VDD VDD VSS VSS gf180mcu_fd_sc_mcu7t5v0__inv_1
Xs_1_25 coarse_s1_24 coarse_s1_25 VDD VDD VSS VSS gf180mcu_fd_sc_mcu7t5v0__inv_1
Xs_1_26 coarse_s1_25 coarse_s1_26 VDD VDD VSS VSS gf180mcu_fd_sc_mcu7t5v0__inv_1
Xs_1_27 coarse_s1_26 coarse_s1_27 VDD VDD VSS VSS gf180mcu_fd_sc_mcu7t5v0__inv_1
Xs_1_28 coarse_s1_27 coarse_s1_28 VDD VDD VSS VSS gf180mcu_fd_sc_mcu7t5v0__inv_1
Xs_1_29 coarse_s1_28 coarse_s1_29 VDD VDD VSS VSS gf180mcu_fd_sc_mcu7t5v0__inv_1
Xs_1_30 coarse_s1_29 coarse_s1_30 VDD VDD VSS VSS gf180mcu_fd_sc_mcu7t5v0__inv_1
Xs_1_31 coarse_s1_30 coarse_s1_31 VDD VDD VSS VSS gf180mcu_fd_sc_mcu7t5v0__inv_1
Xs_1_32 coarse_s1_31 coarse_s1_32 VDD VDD VSS VSS gf180mcu_fd_sc_mcu7t5v0__inv_1
Xs_1_33 coarse_s1_32 coarse_s1_33 VDD VDD VSS VSS gf180mcu_fd_sc_mcu7t5v0__inv_1
Xs_1_34 coarse_s1_33 coarse_s1_34 VDD VDD VSS VSS gf180mcu_fd_sc_mcu7t5v0__inv_1
Xs_1_35 coarse_s1_34 coarse_s1_35 VDD VDD VSS VSS gf180mcu_fd_sc_mcu7t5v0__inv_1
Xs_1_36 coarse_s1_35 coarse_s1_36 VDD VDD VSS VSS gf180mcu_fd_sc_mcu7t5v0__inv_1
Xs_1_37 coarse_s1_36 coarse_s1_37 VDD VDD VSS VSS gf180mcu_fd_sc_mcu7t5v0__inv_1
Xs_1_38 coarse_s1_37 coarse_s1_38 VDD VDD VSS VSS gf180mcu_fd_sc_mcu7t5v0__inv_1
Xs_1_39 coarse_s1_38 coarse_s1_39 VDD VDD VSS VSS gf180mcu_fd_sc_mcu7t5v0__inv_1
Xs_1_40 coarse_s1_39 coarse_s1_40 VDD VDD VSS VSS gf180mcu_fd_sc_mcu7t5v0__inv_1
Xs_1_41 coarse_s1_40 coarse_s1_41 VDD VDD VSS VSS gf180mcu_fd_sc_mcu7t5v0__inv_1
Xs_1_42 coarse_s1_41 coarse_s1_42 VDD VDD VSS VSS gf180mcu_fd_sc_mcu7t5v0__inv_1
Xs_1_43 coarse_s1_42 coarse_s1_43 VDD VDD VSS VSS gf180mcu_fd_sc_mcu7t5v0__inv_1
Xs_1_44 coarse_s1_43 coarse_s1_44 VDD VDD VSS VSS gf180mcu_fd_sc_mcu7t5v0__inv_1
Xs_1_45 coarse_s1_44 coarse_s1_45 VDD VDD VSS VSS gf180mcu_fd_sc_mcu7t5v0__inv_1
Xs_1_46 coarse_s1_45 coarse_s1_46 VDD VDD VSS VSS gf180mcu_fd_sc_mcu7t5v0__inv_1
Xs_1_47 coarse_s1_46 coarse_s1_47 VDD VDD VSS VSS gf180mcu_fd_sc_mcu7t5v0__inv_1
Xs_1_48 coarse_s1_47 coarse_s1_48 VDD VDD VSS VSS gf180mcu_fd_sc_mcu7t5v0__inv_1
Xs_1_49 coarse_s1_48 coarse_s1_49 VDD VDD VSS VSS gf180mcu_fd_sc_mcu7t5v0__inv_1
Xs_1_50 coarse_s1_49 coarse_s1_50 VDD VDD VSS VSS gf180mcu_fd_sc_mcu7t5v0__inv_1
Xs_1_51 coarse_s1_50 coarse_s1_51 VDD VDD VSS VSS gf180mcu_fd_sc_mcu7t5v0__inv_1
Xs_1_52 coarse_s1_51 coarse_s1_52 VDD VDD VSS VSS gf180mcu_fd_sc_mcu7t5v0__inv_1
Xs_1_53 coarse_s1_52 coarse_s1_53 VDD VDD VSS VSS gf180mcu_fd_sc_mcu7t5v0__inv_1
Xs_1_54 coarse_s1_53 coarse_s1_54 VDD VDD VSS VSS gf180mcu_fd_sc_mcu7t5v0__inv_1
Xs_1_55 coarse_s1_54 coarse_s1_55 VDD VDD VSS VSS gf180mcu_fd_sc_mcu7t5v0__inv_1
Xs_1_56 coarse_s1_55 coarse_s1_56 VDD VDD VSS VSS gf180mcu_fd_sc_mcu7t5v0__inv_1
Xs_1_57 coarse_s1_56 coarse_s1_57 VDD VDD VSS VSS gf180mcu_fd_sc_mcu7t5v0__inv_1
Xs_1_58 coarse_s1_57 coarse_s1_58 VDD VDD VSS VSS gf180mcu_fd_sc_mcu7t5v0__inv_1
Xs_1_59 coarse_s1_58 coarse_s1_59 VDD VDD VSS VSS gf180mcu_fd_sc_mcu7t5v0__inv_1
Xs_1_60 coarse_s1_59 coarse_s1_60 VDD VDD VSS VSS gf180mcu_fd_sc_mcu7t5v0__inv_1
Xs_1_61 coarse_s1_60 coarse_s1_61 VDD VDD VSS VSS gf180mcu_fd_sc_mcu7t5v0__inv_1
Xs_1_62 coarse_s1_61 coarse_s1_62 VDD VDD VSS VSS gf180mcu_fd_sc_mcu7t5v0__inv_1
Xs_1_63 coarse_s1_62 coarse_s1_63 VDD VDD VSS VSS gf180mcu_fd_sc_mcu7t5v0__inv_1
Xs_1_64 coarse_s1_63 coarse_s1_64 VDD VDD VSS VSS gf180mcu_fd_sc_mcu7t5v0__inv_1
Xs_1_65 coarse_s1_64 coarse_s1_65 VDD VDD VSS VSS gf180mcu_fd_sc_mcu7t5v0__inv_1
Xs_1_66 coarse_s1_65 coarse_s1_66 VDD VDD VSS VSS gf180mcu_fd_sc_mcu7t5v0__inv_1
Xs_1_67 coarse_s1_66 coarse_s1_67 VDD VDD VSS VSS gf180mcu_fd_sc_mcu7t5v0__inv_1
Xs_1_68 coarse_s1_67 coarse_s1_68 VDD VDD VSS VSS gf180mcu_fd_sc_mcu7t5v0__inv_1
Xs_1_69 coarse_s1_68 coarse_s1_69 VDD VDD VSS VSS gf180mcu_fd_sc_mcu7t5v0__inv_1
Xs_1_70 coarse_s1_69 coarse_s1_70 VDD VDD VSS VSS gf180mcu_fd_sc_mcu7t5v0__inv_1
Xs_1_71 coarse_s1_70 coarse_s1_71 VDD VDD VSS VSS gf180mcu_fd_sc_mcu7t5v0__inv_1
Xs_1_72 coarse_s1_71 coarse_s1_72 VDD VDD VSS VSS gf180mcu_fd_sc_mcu7t5v0__inv_1
Xs_1_73 coarse_s1_72 coarse_s1_73 VDD VDD VSS VSS gf180mcu_fd_sc_mcu7t5v0__inv_1
Xs_1_74 coarse_s1_73 coarse_s1_74 VDD VDD VSS VSS gf180mcu_fd_sc_mcu7t5v0__inv_1
Xs_1_75 coarse_s1_74 coarse_s1_75 VDD VDD VSS VSS gf180mcu_fd_sc_mcu7t5v0__inv_1
Xs_1_76 coarse_s1_75 coarse_s1_76 VDD VDD VSS VSS gf180mcu_fd_sc_mcu7t5v0__inv_1
Xs_1_77 coarse_s1_76 coarse_s1_77 VDD VDD VSS VSS gf180mcu_fd_sc_mcu7t5v0__inv_1
Xs_1_78 coarse_s1_77 coarse_s1_78 VDD VDD VSS VSS gf180mcu_fd_sc_mcu7t5v0__inv_1
Xs_1_79 coarse_s1_78 coarse_s1_79 VDD VDD VSS VSS gf180mcu_fd_sc_mcu7t5v0__inv_1
Xs_1_80 coarse_s1_79 coarse_s1_80 VDD VDD VSS VSS gf180mcu_fd_sc_mcu7t5v0__inv_1
Xs_1_81 coarse_s1_80 coarse_s1_81 VDD VDD VSS VSS gf180mcu_fd_sc_mcu7t5v0__inv_1
Xs_1_82 coarse_s1_81 coarse_s1_82 VDD VDD VSS VSS gf180mcu_fd_sc_mcu7t5v0__inv_1
Xs_1_83 coarse_s1_82 coarse_s1_83 VDD VDD VSS VSS gf180mcu_fd_sc_mcu7t5v0__inv_1
Xs_1_84 coarse_s1_83 coarse_s1_84 VDD VDD VSS VSS gf180mcu_fd_sc_mcu7t5v0__inv_1
Xs_1_85 coarse_s1_84 coarse_s1_85 VDD VDD VSS VSS gf180mcu_fd_sc_mcu7t5v0__inv_1
Xs_1_86 coarse_s1_85 coarse_s1_86 VDD VDD VSS VSS gf180mcu_fd_sc_mcu7t5v0__inv_1
Xs_1_87 coarse_s1_86 coarse_s1_87 VDD VDD VSS VSS gf180mcu_fd_sc_mcu7t5v0__inv_1
Xs_1_88 coarse_s1_87 coarse_s1_88 VDD VDD VSS VSS gf180mcu_fd_sc_mcu7t5v0__inv_1
Xs_1_89 coarse_s1_88 coarse_tap_s1 VDD VDD VSS VSS gf180mcu_fd_sc_mcu7t5v0__inv_1
Xs_2_0 coarse_tap_s1 coarse_s2_0 VDD VDD VSS VSS gf180mcu_fd_sc_mcu7t5v0__inv_1
Xs_2_1 coarse_s2_0 coarse_s2_1 VDD VDD VSS VSS gf180mcu_fd_sc_mcu7t5v0__inv_1
Xs_2_2 coarse_s2_1 coarse_s2_2 VDD VDD VSS VSS gf180mcu_fd_sc_mcu7t5v0__inv_1
Xs_2_3 coarse_s2_2 coarse_s2_3 VDD VDD VSS VSS gf180mcu_fd_sc_mcu7t5v0__inv_1
Xs_2_4 coarse_s2_3 coarse_s2_4 VDD VDD VSS VSS gf180mcu_fd_sc_mcu7t5v0__inv_1
Xs_2_5 coarse_s2_4 coarse_s2_5 VDD VDD VSS VSS gf180mcu_fd_sc_mcu7t5v0__inv_1
Xs_2_6 coarse_s2_5 coarse_s2_6 VDD VDD VSS VSS gf180mcu_fd_sc_mcu7t5v0__inv_1
Xs_2_7 coarse_s2_6 coarse_s2_7 VDD VDD VSS VSS gf180mcu_fd_sc_mcu7t5v0__inv_1
Xs_2_8 coarse_s2_7 coarse_s2_8 VDD VDD VSS VSS gf180mcu_fd_sc_mcu7t5v0__inv_1
Xs_2_9 coarse_s2_8 coarse_s2_9 VDD VDD VSS VSS gf180mcu_fd_sc_mcu7t5v0__inv_1
Xs_2_10 coarse_s2_9 coarse_s2_10 VDD VDD VSS VSS gf180mcu_fd_sc_mcu7t5v0__inv_1
Xs_2_11 coarse_s2_10 coarse_s2_11 VDD VDD VSS VSS gf180mcu_fd_sc_mcu7t5v0__inv_1
Xs_2_12 coarse_s2_11 coarse_s2_12 VDD VDD VSS VSS gf180mcu_fd_sc_mcu7t5v0__inv_1
Xs_2_13 coarse_s2_12 coarse_s2_13 VDD VDD VSS VSS gf180mcu_fd_sc_mcu7t5v0__inv_1
Xs_2_14 coarse_s2_13 coarse_s2_14 VDD VDD VSS VSS gf180mcu_fd_sc_mcu7t5v0__inv_1
Xs_2_15 coarse_s2_14 coarse_s2_15 VDD VDD VSS VSS gf180mcu_fd_sc_mcu7t5v0__inv_1
Xs_2_16 coarse_s2_15 coarse_s2_16 VDD VDD VSS VSS gf180mcu_fd_sc_mcu7t5v0__inv_1
Xs_2_17 coarse_s2_16 coarse_s2_17 VDD VDD VSS VSS gf180mcu_fd_sc_mcu7t5v0__inv_1
Xs_2_18 coarse_s2_17 coarse_s2_18 VDD VDD VSS VSS gf180mcu_fd_sc_mcu7t5v0__inv_1
Xs_2_19 coarse_s2_18 coarse_s2_19 VDD VDD VSS VSS gf180mcu_fd_sc_mcu7t5v0__inv_1
Xs_2_20 coarse_s2_19 coarse_s2_20 VDD VDD VSS VSS gf180mcu_fd_sc_mcu7t5v0__inv_1
Xs_2_21 coarse_s2_20 coarse_s2_21 VDD VDD VSS VSS gf180mcu_fd_sc_mcu7t5v0__inv_1
Xs_2_22 coarse_s2_21 coarse_s2_22 VDD VDD VSS VSS gf180mcu_fd_sc_mcu7t5v0__inv_1
Xs_2_23 coarse_s2_22 coarse_s2_23 VDD VDD VSS VSS gf180mcu_fd_sc_mcu7t5v0__inv_1
Xs_2_24 coarse_s2_23 coarse_s2_24 VDD VDD VSS VSS gf180mcu_fd_sc_mcu7t5v0__inv_1
Xs_2_25 coarse_s2_24 coarse_s2_25 VDD VDD VSS VSS gf180mcu_fd_sc_mcu7t5v0__inv_1
Xs_2_26 coarse_s2_25 coarse_s2_26 VDD VDD VSS VSS gf180mcu_fd_sc_mcu7t5v0__inv_1
Xs_2_27 coarse_s2_26 coarse_s2_27 VDD VDD VSS VSS gf180mcu_fd_sc_mcu7t5v0__inv_1
Xs_2_28 coarse_s2_27 coarse_s2_28 VDD VDD VSS VSS gf180mcu_fd_sc_mcu7t5v0__inv_1
Xs_2_29 coarse_s2_28 coarse_s2_29 VDD VDD VSS VSS gf180mcu_fd_sc_mcu7t5v0__inv_1
Xs_2_30 coarse_s2_29 coarse_s2_30 VDD VDD VSS VSS gf180mcu_fd_sc_mcu7t5v0__inv_1
Xs_2_31 coarse_s2_30 coarse_s2_31 VDD VDD VSS VSS gf180mcu_fd_sc_mcu7t5v0__inv_1
Xs_2_32 coarse_s2_31 coarse_s2_32 VDD VDD VSS VSS gf180mcu_fd_sc_mcu7t5v0__inv_1
Xs_2_33 coarse_s2_32 coarse_s2_33 VDD VDD VSS VSS gf180mcu_fd_sc_mcu7t5v0__inv_1
Xs_2_34 coarse_s2_33 coarse_s2_34 VDD VDD VSS VSS gf180mcu_fd_sc_mcu7t5v0__inv_1
Xs_2_35 coarse_s2_34 coarse_s2_35 VDD VDD VSS VSS gf180mcu_fd_sc_mcu7t5v0__inv_1
Xs_2_36 coarse_s2_35 coarse_s2_36 VDD VDD VSS VSS gf180mcu_fd_sc_mcu7t5v0__inv_1
Xs_2_37 coarse_s2_36 coarse_s2_37 VDD VDD VSS VSS gf180mcu_fd_sc_mcu7t5v0__inv_1
Xs_2_38 coarse_s2_37 coarse_s2_38 VDD VDD VSS VSS gf180mcu_fd_sc_mcu7t5v0__inv_1
Xs_2_39 coarse_s2_38 coarse_s2_39 VDD VDD VSS VSS gf180mcu_fd_sc_mcu7t5v0__inv_1
Xs_2_40 coarse_s2_39 coarse_s2_40 VDD VDD VSS VSS gf180mcu_fd_sc_mcu7t5v0__inv_1
Xs_2_41 coarse_s2_40 coarse_s2_41 VDD VDD VSS VSS gf180mcu_fd_sc_mcu7t5v0__inv_1
Xs_2_42 coarse_s2_41 coarse_s2_42 VDD VDD VSS VSS gf180mcu_fd_sc_mcu7t5v0__inv_1
Xs_2_43 coarse_s2_42 coarse_s2_43 VDD VDD VSS VSS gf180mcu_fd_sc_mcu7t5v0__inv_1
Xs_2_44 coarse_s2_43 coarse_s2_44 VDD VDD VSS VSS gf180mcu_fd_sc_mcu7t5v0__inv_1
Xs_2_45 coarse_s2_44 coarse_s2_45 VDD VDD VSS VSS gf180mcu_fd_sc_mcu7t5v0__inv_1
Xs_2_46 coarse_s2_45 coarse_s2_46 VDD VDD VSS VSS gf180mcu_fd_sc_mcu7t5v0__inv_1
Xs_2_47 coarse_s2_46 coarse_s2_47 VDD VDD VSS VSS gf180mcu_fd_sc_mcu7t5v0__inv_1
Xs_2_48 coarse_s2_47 coarse_s2_48 VDD VDD VSS VSS gf180mcu_fd_sc_mcu7t5v0__inv_1
Xs_2_49 coarse_s2_48 coarse_s2_49 VDD VDD VSS VSS gf180mcu_fd_sc_mcu7t5v0__inv_1
Xs_2_50 coarse_s2_49 coarse_s2_50 VDD VDD VSS VSS gf180mcu_fd_sc_mcu7t5v0__inv_1
Xs_2_51 coarse_s2_50 coarse_s2_51 VDD VDD VSS VSS gf180mcu_fd_sc_mcu7t5v0__inv_1
Xs_2_52 coarse_s2_51 coarse_s2_52 VDD VDD VSS VSS gf180mcu_fd_sc_mcu7t5v0__inv_1
Xs_2_53 coarse_s2_52 coarse_s2_53 VDD VDD VSS VSS gf180mcu_fd_sc_mcu7t5v0__inv_1
Xs_2_54 coarse_s2_53 coarse_s2_54 VDD VDD VSS VSS gf180mcu_fd_sc_mcu7t5v0__inv_1
Xs_2_55 coarse_s2_54 coarse_s2_55 VDD VDD VSS VSS gf180mcu_fd_sc_mcu7t5v0__inv_1
Xs_2_56 coarse_s2_55 coarse_s2_56 VDD VDD VSS VSS gf180mcu_fd_sc_mcu7t5v0__inv_1
Xs_2_57 coarse_s2_56 coarse_s2_57 VDD VDD VSS VSS gf180mcu_fd_sc_mcu7t5v0__inv_1
Xs_2_58 coarse_s2_57 coarse_s2_58 VDD VDD VSS VSS gf180mcu_fd_sc_mcu7t5v0__inv_1
Xs_2_59 coarse_s2_58 coarse_s2_59 VDD VDD VSS VSS gf180mcu_fd_sc_mcu7t5v0__inv_1
Xs_2_60 coarse_s2_59 coarse_s2_60 VDD VDD VSS VSS gf180mcu_fd_sc_mcu7t5v0__inv_1
Xs_2_61 coarse_s2_60 coarse_s2_61 VDD VDD VSS VSS gf180mcu_fd_sc_mcu7t5v0__inv_1
Xs_2_62 coarse_s2_61 coarse_s2_62 VDD VDD VSS VSS gf180mcu_fd_sc_mcu7t5v0__inv_1
Xs_2_63 coarse_s2_62 coarse_s2_63 VDD VDD VSS VSS gf180mcu_fd_sc_mcu7t5v0__inv_1
Xs_2_64 coarse_s2_63 coarse_s2_64 VDD VDD VSS VSS gf180mcu_fd_sc_mcu7t5v0__inv_1
Xs_2_65 coarse_s2_64 coarse_s2_65 VDD VDD VSS VSS gf180mcu_fd_sc_mcu7t5v0__inv_1
Xs_2_66 coarse_s2_65 coarse_s2_66 VDD VDD VSS VSS gf180mcu_fd_sc_mcu7t5v0__inv_1
Xs_2_67 coarse_s2_66 coarse_s2_67 VDD VDD VSS VSS gf180mcu_fd_sc_mcu7t5v0__inv_1
Xs_2_68 coarse_s2_67 coarse_s2_68 VDD VDD VSS VSS gf180mcu_fd_sc_mcu7t5v0__inv_1
Xs_2_69 coarse_s2_68 coarse_s2_69 VDD VDD VSS VSS gf180mcu_fd_sc_mcu7t5v0__inv_1
Xs_2_70 coarse_s2_69 coarse_s2_70 VDD VDD VSS VSS gf180mcu_fd_sc_mcu7t5v0__inv_1
Xs_2_71 coarse_s2_70 coarse_s2_71 VDD VDD VSS VSS gf180mcu_fd_sc_mcu7t5v0__inv_1
Xs_2_72 coarse_s2_71 coarse_s2_72 VDD VDD VSS VSS gf180mcu_fd_sc_mcu7t5v0__inv_1
Xs_2_73 coarse_s2_72 coarse_s2_73 VDD VDD VSS VSS gf180mcu_fd_sc_mcu7t5v0__inv_1
Xs_2_74 coarse_s2_73 coarse_s2_74 VDD VDD VSS VSS gf180mcu_fd_sc_mcu7t5v0__inv_1
Xs_2_75 coarse_s2_74 coarse_s2_75 VDD VDD VSS VSS gf180mcu_fd_sc_mcu7t5v0__inv_1
Xs_2_76 coarse_s2_75 coarse_s2_76 VDD VDD VSS VSS gf180mcu_fd_sc_mcu7t5v0__inv_1
Xs_2_77 coarse_s2_76 coarse_s2_77 VDD VDD VSS VSS gf180mcu_fd_sc_mcu7t5v0__inv_1
Xs_2_78 coarse_s2_77 coarse_s2_78 VDD VDD VSS VSS gf180mcu_fd_sc_mcu7t5v0__inv_1
Xs_2_79 coarse_s2_78 coarse_s2_79 VDD VDD VSS VSS gf180mcu_fd_sc_mcu7t5v0__inv_1
Xs_2_80 coarse_s2_79 coarse_s2_80 VDD VDD VSS VSS gf180mcu_fd_sc_mcu7t5v0__inv_1
Xs_2_81 coarse_s2_80 coarse_s2_81 VDD VDD VSS VSS gf180mcu_fd_sc_mcu7t5v0__inv_1
Xs_2_82 coarse_s2_81 coarse_s2_82 VDD VDD VSS VSS gf180mcu_fd_sc_mcu7t5v0__inv_1
Xs_2_83 coarse_s2_82 coarse_s2_83 VDD VDD VSS VSS gf180mcu_fd_sc_mcu7t5v0__inv_1
Xs_2_84 coarse_s2_83 coarse_s2_84 VDD VDD VSS VSS gf180mcu_fd_sc_mcu7t5v0__inv_1
Xs_2_85 coarse_s2_84 coarse_s2_85 VDD VDD VSS VSS gf180mcu_fd_sc_mcu7t5v0__inv_1
Xs_2_86 coarse_s2_85 coarse_s2_86 VDD VDD VSS VSS gf180mcu_fd_sc_mcu7t5v0__inv_1
Xs_2_87 coarse_s2_86 coarse_s2_87 VDD VDD VSS VSS gf180mcu_fd_sc_mcu7t5v0__inv_1
Xs_2_88 coarse_s2_87 coarse_s2_88 VDD VDD VSS VSS gf180mcu_fd_sc_mcu7t5v0__inv_1
Xs_2_89 coarse_s2_88 coarse_tap_s2 VDD VDD VSS VSS gf180mcu_fd_sc_mcu7t5v0__inv_1
Xs_3_0 coarse_tap_s2 coarse_s3_0 VDD VDD VSS VSS gf180mcu_fd_sc_mcu7t5v0__inv_1
Xs_3_1 coarse_s3_0 coarse_s3_1 VDD VDD VSS VSS gf180mcu_fd_sc_mcu7t5v0__inv_1
Xs_3_2 coarse_s3_1 coarse_s3_2 VDD VDD VSS VSS gf180mcu_fd_sc_mcu7t5v0__inv_1
Xs_3_3 coarse_s3_2 coarse_s3_3 VDD VDD VSS VSS gf180mcu_fd_sc_mcu7t5v0__inv_1
Xs_3_4 coarse_s3_3 coarse_s3_4 VDD VDD VSS VSS gf180mcu_fd_sc_mcu7t5v0__inv_1
Xs_3_5 coarse_s3_4 coarse_s3_5 VDD VDD VSS VSS gf180mcu_fd_sc_mcu7t5v0__inv_1
Xs_3_6 coarse_s3_5 coarse_s3_6 VDD VDD VSS VSS gf180mcu_fd_sc_mcu7t5v0__inv_1
Xs_3_7 coarse_s3_6 coarse_s3_7 VDD VDD VSS VSS gf180mcu_fd_sc_mcu7t5v0__inv_1
Xs_3_8 coarse_s3_7 coarse_s3_8 VDD VDD VSS VSS gf180mcu_fd_sc_mcu7t5v0__inv_1
Xs_3_9 coarse_s3_8 coarse_s3_9 VDD VDD VSS VSS gf180mcu_fd_sc_mcu7t5v0__inv_1
Xs_3_10 coarse_s3_9 coarse_s3_10 VDD VDD VSS VSS gf180mcu_fd_sc_mcu7t5v0__inv_1
Xs_3_11 coarse_s3_10 coarse_s3_11 VDD VDD VSS VSS gf180mcu_fd_sc_mcu7t5v0__inv_1
Xs_3_12 coarse_s3_11 coarse_s3_12 VDD VDD VSS VSS gf180mcu_fd_sc_mcu7t5v0__inv_1
Xs_3_13 coarse_s3_12 coarse_s3_13 VDD VDD VSS VSS gf180mcu_fd_sc_mcu7t5v0__inv_1
Xs_3_14 coarse_s3_13 coarse_s3_14 VDD VDD VSS VSS gf180mcu_fd_sc_mcu7t5v0__inv_1
Xs_3_15 coarse_s3_14 coarse_s3_15 VDD VDD VSS VSS gf180mcu_fd_sc_mcu7t5v0__inv_1
Xs_3_16 coarse_s3_15 coarse_s3_16 VDD VDD VSS VSS gf180mcu_fd_sc_mcu7t5v0__inv_1
Xs_3_17 coarse_s3_16 coarse_s3_17 VDD VDD VSS VSS gf180mcu_fd_sc_mcu7t5v0__inv_1
Xs_3_18 coarse_s3_17 coarse_s3_18 VDD VDD VSS VSS gf180mcu_fd_sc_mcu7t5v0__inv_1
Xs_3_19 coarse_s3_18 coarse_s3_19 VDD VDD VSS VSS gf180mcu_fd_sc_mcu7t5v0__inv_1
Xs_3_20 coarse_s3_19 coarse_s3_20 VDD VDD VSS VSS gf180mcu_fd_sc_mcu7t5v0__inv_1
Xs_3_21 coarse_s3_20 coarse_s3_21 VDD VDD VSS VSS gf180mcu_fd_sc_mcu7t5v0__inv_1
Xs_3_22 coarse_s3_21 coarse_s3_22 VDD VDD VSS VSS gf180mcu_fd_sc_mcu7t5v0__inv_1
Xs_3_23 coarse_s3_22 coarse_s3_23 VDD VDD VSS VSS gf180mcu_fd_sc_mcu7t5v0__inv_1
Xs_3_24 coarse_s3_23 coarse_s3_24 VDD VDD VSS VSS gf180mcu_fd_sc_mcu7t5v0__inv_1
Xs_3_25 coarse_s3_24 coarse_s3_25 VDD VDD VSS VSS gf180mcu_fd_sc_mcu7t5v0__inv_1
Xs_3_26 coarse_s3_25 coarse_s3_26 VDD VDD VSS VSS gf180mcu_fd_sc_mcu7t5v0__inv_1
Xs_3_27 coarse_s3_26 coarse_s3_27 VDD VDD VSS VSS gf180mcu_fd_sc_mcu7t5v0__inv_1
Xs_3_28 coarse_s3_27 coarse_s3_28 VDD VDD VSS VSS gf180mcu_fd_sc_mcu7t5v0__inv_1
Xs_3_29 coarse_s3_28 coarse_s3_29 VDD VDD VSS VSS gf180mcu_fd_sc_mcu7t5v0__inv_1
Xs_3_30 coarse_s3_29 coarse_s3_30 VDD VDD VSS VSS gf180mcu_fd_sc_mcu7t5v0__inv_1
Xs_3_31 coarse_s3_30 coarse_s3_31 VDD VDD VSS VSS gf180mcu_fd_sc_mcu7t5v0__inv_1
Xs_3_32 coarse_s3_31 coarse_s3_32 VDD VDD VSS VSS gf180mcu_fd_sc_mcu7t5v0__inv_1
Xs_3_33 coarse_s3_32 coarse_s3_33 VDD VDD VSS VSS gf180mcu_fd_sc_mcu7t5v0__inv_1
Xs_3_34 coarse_s3_33 coarse_s3_34 VDD VDD VSS VSS gf180mcu_fd_sc_mcu7t5v0__inv_1
Xs_3_35 coarse_s3_34 coarse_s3_35 VDD VDD VSS VSS gf180mcu_fd_sc_mcu7t5v0__inv_1
Xs_3_36 coarse_s3_35 coarse_s3_36 VDD VDD VSS VSS gf180mcu_fd_sc_mcu7t5v0__inv_1
Xs_3_37 coarse_s3_36 coarse_s3_37 VDD VDD VSS VSS gf180mcu_fd_sc_mcu7t5v0__inv_1
Xs_3_38 coarse_s3_37 coarse_s3_38 VDD VDD VSS VSS gf180mcu_fd_sc_mcu7t5v0__inv_1
Xs_3_39 coarse_s3_38 coarse_s3_39 VDD VDD VSS VSS gf180mcu_fd_sc_mcu7t5v0__inv_1
Xs_3_40 coarse_s3_39 coarse_s3_40 VDD VDD VSS VSS gf180mcu_fd_sc_mcu7t5v0__inv_1
Xs_3_41 coarse_s3_40 coarse_s3_41 VDD VDD VSS VSS gf180mcu_fd_sc_mcu7t5v0__inv_1
Xs_3_42 coarse_s3_41 coarse_s3_42 VDD VDD VSS VSS gf180mcu_fd_sc_mcu7t5v0__inv_1
Xs_3_43 coarse_s3_42 coarse_s3_43 VDD VDD VSS VSS gf180mcu_fd_sc_mcu7t5v0__inv_1
Xs_3_44 coarse_s3_43 coarse_s3_44 VDD VDD VSS VSS gf180mcu_fd_sc_mcu7t5v0__inv_1
Xs_3_45 coarse_s3_44 coarse_s3_45 VDD VDD VSS VSS gf180mcu_fd_sc_mcu7t5v0__inv_1
Xs_3_46 coarse_s3_45 coarse_s3_46 VDD VDD VSS VSS gf180mcu_fd_sc_mcu7t5v0__inv_1
Xs_3_47 coarse_s3_46 coarse_s3_47 VDD VDD VSS VSS gf180mcu_fd_sc_mcu7t5v0__inv_1
Xs_3_48 coarse_s3_47 coarse_s3_48 VDD VDD VSS VSS gf180mcu_fd_sc_mcu7t5v0__inv_1
Xs_3_49 coarse_s3_48 coarse_s3_49 VDD VDD VSS VSS gf180mcu_fd_sc_mcu7t5v0__inv_1
Xs_3_50 coarse_s3_49 coarse_s3_50 VDD VDD VSS VSS gf180mcu_fd_sc_mcu7t5v0__inv_1
Xs_3_51 coarse_s3_50 coarse_s3_51 VDD VDD VSS VSS gf180mcu_fd_sc_mcu7t5v0__inv_1
Xs_3_52 coarse_s3_51 coarse_s3_52 VDD VDD VSS VSS gf180mcu_fd_sc_mcu7t5v0__inv_1
Xs_3_53 coarse_s3_52 coarse_s3_53 VDD VDD VSS VSS gf180mcu_fd_sc_mcu7t5v0__inv_1
Xs_3_54 coarse_s3_53 coarse_s3_54 VDD VDD VSS VSS gf180mcu_fd_sc_mcu7t5v0__inv_1
Xs_3_55 coarse_s3_54 coarse_s3_55 VDD VDD VSS VSS gf180mcu_fd_sc_mcu7t5v0__inv_1
Xs_3_56 coarse_s3_55 coarse_s3_56 VDD VDD VSS VSS gf180mcu_fd_sc_mcu7t5v0__inv_1
Xs_3_57 coarse_s3_56 coarse_s3_57 VDD VDD VSS VSS gf180mcu_fd_sc_mcu7t5v0__inv_1
Xs_3_58 coarse_s3_57 coarse_s3_58 VDD VDD VSS VSS gf180mcu_fd_sc_mcu7t5v0__inv_1
Xs_3_59 coarse_s3_58 coarse_s3_59 VDD VDD VSS VSS gf180mcu_fd_sc_mcu7t5v0__inv_1
Xs_3_60 coarse_s3_59 coarse_s3_60 VDD VDD VSS VSS gf180mcu_fd_sc_mcu7t5v0__inv_1
Xs_3_61 coarse_s3_60 coarse_s3_61 VDD VDD VSS VSS gf180mcu_fd_sc_mcu7t5v0__inv_1
Xs_3_62 coarse_s3_61 coarse_s3_62 VDD VDD VSS VSS gf180mcu_fd_sc_mcu7t5v0__inv_1
Xs_3_63 coarse_s3_62 coarse_s3_63 VDD VDD VSS VSS gf180mcu_fd_sc_mcu7t5v0__inv_1
Xs_3_64 coarse_s3_63 coarse_s3_64 VDD VDD VSS VSS gf180mcu_fd_sc_mcu7t5v0__inv_1
Xs_3_65 coarse_s3_64 coarse_s3_65 VDD VDD VSS VSS gf180mcu_fd_sc_mcu7t5v0__inv_1
Xs_3_66 coarse_s3_65 coarse_s3_66 VDD VDD VSS VSS gf180mcu_fd_sc_mcu7t5v0__inv_1
Xs_3_67 coarse_s3_66 coarse_s3_67 VDD VDD VSS VSS gf180mcu_fd_sc_mcu7t5v0__inv_1
Xs_3_68 coarse_s3_67 coarse_s3_68 VDD VDD VSS VSS gf180mcu_fd_sc_mcu7t5v0__inv_1
Xs_3_69 coarse_s3_68 coarse_s3_69 VDD VDD VSS VSS gf180mcu_fd_sc_mcu7t5v0__inv_1
Xs_3_70 coarse_s3_69 coarse_s3_70 VDD VDD VSS VSS gf180mcu_fd_sc_mcu7t5v0__inv_1
Xs_3_71 coarse_s3_70 coarse_s3_71 VDD VDD VSS VSS gf180mcu_fd_sc_mcu7t5v0__inv_1
Xs_3_72 coarse_s3_71 coarse_s3_72 VDD VDD VSS VSS gf180mcu_fd_sc_mcu7t5v0__inv_1
Xs_3_73 coarse_s3_72 coarse_s3_73 VDD VDD VSS VSS gf180mcu_fd_sc_mcu7t5v0__inv_1
Xs_3_74 coarse_s3_73 coarse_s3_74 VDD VDD VSS VSS gf180mcu_fd_sc_mcu7t5v0__inv_1
Xs_3_75 coarse_s3_74 coarse_s3_75 VDD VDD VSS VSS gf180mcu_fd_sc_mcu7t5v0__inv_1
Xs_3_76 coarse_s3_75 coarse_s3_76 VDD VDD VSS VSS gf180mcu_fd_sc_mcu7t5v0__inv_1
Xs_3_77 coarse_s3_76 coarse_s3_77 VDD VDD VSS VSS gf180mcu_fd_sc_mcu7t5v0__inv_1
Xs_3_78 coarse_s3_77 coarse_s3_78 VDD VDD VSS VSS gf180mcu_fd_sc_mcu7t5v0__inv_1
Xs_3_79 coarse_s3_78 coarse_s3_79 VDD VDD VSS VSS gf180mcu_fd_sc_mcu7t5v0__inv_1
Xs_3_80 coarse_s3_79 coarse_s3_80 VDD VDD VSS VSS gf180mcu_fd_sc_mcu7t5v0__inv_1
Xs_3_81 coarse_s3_80 coarse_s3_81 VDD VDD VSS VSS gf180mcu_fd_sc_mcu7t5v0__inv_1
Xs_3_82 coarse_s3_81 coarse_s3_82 VDD VDD VSS VSS gf180mcu_fd_sc_mcu7t5v0__inv_1
Xs_3_83 coarse_s3_82 coarse_s3_83 VDD VDD VSS VSS gf180mcu_fd_sc_mcu7t5v0__inv_1
Xs_3_84 coarse_s3_83 coarse_s3_84 VDD VDD VSS VSS gf180mcu_fd_sc_mcu7t5v0__inv_1
Xs_3_85 coarse_s3_84 coarse_s3_85 VDD VDD VSS VSS gf180mcu_fd_sc_mcu7t5v0__inv_1
Xs_3_86 coarse_s3_85 coarse_s3_86 VDD VDD VSS VSS gf180mcu_fd_sc_mcu7t5v0__inv_1
Xs_3_87 coarse_s3_86 coarse_s3_87 VDD VDD VSS VSS gf180mcu_fd_sc_mcu7t5v0__inv_1
Xs_3_88 coarse_s3_87 coarse_s3_88 VDD VDD VSS VSS gf180mcu_fd_sc_mcu7t5v0__inv_1
Xs_3_89 coarse_s3_88 coarse_tap_s3 VDD VDD VSS VSS gf180mcu_fd_sc_mcu7t5v0__inv_1
Xs_4_0 coarse_tap_s3 coarse_s4_0 VDD VDD VSS VSS gf180mcu_fd_sc_mcu7t5v0__inv_1
Xs_4_1 coarse_s4_0 coarse_s4_1 VDD VDD VSS VSS gf180mcu_fd_sc_mcu7t5v0__inv_1
Xs_4_2 coarse_s4_1 coarse_s4_2 VDD VDD VSS VSS gf180mcu_fd_sc_mcu7t5v0__inv_1
Xs_4_3 coarse_s4_2 coarse_s4_3 VDD VDD VSS VSS gf180mcu_fd_sc_mcu7t5v0__inv_1
Xs_4_4 coarse_s4_3 coarse_s4_4 VDD VDD VSS VSS gf180mcu_fd_sc_mcu7t5v0__inv_1
Xs_4_5 coarse_s4_4 coarse_s4_5 VDD VDD VSS VSS gf180mcu_fd_sc_mcu7t5v0__inv_1
Xs_4_6 coarse_s4_5 coarse_s4_6 VDD VDD VSS VSS gf180mcu_fd_sc_mcu7t5v0__inv_1
Xs_4_7 coarse_s4_6 coarse_s4_7 VDD VDD VSS VSS gf180mcu_fd_sc_mcu7t5v0__inv_1
Xs_4_8 coarse_s4_7 coarse_s4_8 VDD VDD VSS VSS gf180mcu_fd_sc_mcu7t5v0__inv_1
Xs_4_9 coarse_s4_8 coarse_s4_9 VDD VDD VSS VSS gf180mcu_fd_sc_mcu7t5v0__inv_1
Xs_4_10 coarse_s4_9 coarse_s4_10 VDD VDD VSS VSS gf180mcu_fd_sc_mcu7t5v0__inv_1
Xs_4_11 coarse_s4_10 coarse_s4_11 VDD VDD VSS VSS gf180mcu_fd_sc_mcu7t5v0__inv_1
Xs_4_12 coarse_s4_11 coarse_s4_12 VDD VDD VSS VSS gf180mcu_fd_sc_mcu7t5v0__inv_1
Xs_4_13 coarse_s4_12 coarse_s4_13 VDD VDD VSS VSS gf180mcu_fd_sc_mcu7t5v0__inv_1
Xs_4_14 coarse_s4_13 coarse_s4_14 VDD VDD VSS VSS gf180mcu_fd_sc_mcu7t5v0__inv_1
Xs_4_15 coarse_s4_14 coarse_s4_15 VDD VDD VSS VSS gf180mcu_fd_sc_mcu7t5v0__inv_1
Xs_4_16 coarse_s4_15 coarse_s4_16 VDD VDD VSS VSS gf180mcu_fd_sc_mcu7t5v0__inv_1
Xs_4_17 coarse_s4_16 coarse_s4_17 VDD VDD VSS VSS gf180mcu_fd_sc_mcu7t5v0__inv_1
Xs_4_18 coarse_s4_17 coarse_s4_18 VDD VDD VSS VSS gf180mcu_fd_sc_mcu7t5v0__inv_1
Xs_4_19 coarse_s4_18 coarse_s4_19 VDD VDD VSS VSS gf180mcu_fd_sc_mcu7t5v0__inv_1
Xs_4_20 coarse_s4_19 coarse_s4_20 VDD VDD VSS VSS gf180mcu_fd_sc_mcu7t5v0__inv_1
Xs_4_21 coarse_s4_20 coarse_s4_21 VDD VDD VSS VSS gf180mcu_fd_sc_mcu7t5v0__inv_1
Xs_4_22 coarse_s4_21 coarse_s4_22 VDD VDD VSS VSS gf180mcu_fd_sc_mcu7t5v0__inv_1
Xs_4_23 coarse_s4_22 coarse_s4_23 VDD VDD VSS VSS gf180mcu_fd_sc_mcu7t5v0__inv_1
Xs_4_24 coarse_s4_23 coarse_s4_24 VDD VDD VSS VSS gf180mcu_fd_sc_mcu7t5v0__inv_1
Xs_4_25 coarse_s4_24 coarse_s4_25 VDD VDD VSS VSS gf180mcu_fd_sc_mcu7t5v0__inv_1
Xs_4_26 coarse_s4_25 coarse_s4_26 VDD VDD VSS VSS gf180mcu_fd_sc_mcu7t5v0__inv_1
Xs_4_27 coarse_s4_26 coarse_s4_27 VDD VDD VSS VSS gf180mcu_fd_sc_mcu7t5v0__inv_1
Xs_4_28 coarse_s4_27 coarse_s4_28 VDD VDD VSS VSS gf180mcu_fd_sc_mcu7t5v0__inv_1
Xs_4_29 coarse_s4_28 coarse_s4_29 VDD VDD VSS VSS gf180mcu_fd_sc_mcu7t5v0__inv_1
Xs_4_30 coarse_s4_29 coarse_s4_30 VDD VDD VSS VSS gf180mcu_fd_sc_mcu7t5v0__inv_1
Xs_4_31 coarse_s4_30 coarse_s4_31 VDD VDD VSS VSS gf180mcu_fd_sc_mcu7t5v0__inv_1
Xs_4_32 coarse_s4_31 coarse_s4_32 VDD VDD VSS VSS gf180mcu_fd_sc_mcu7t5v0__inv_1
Xs_4_33 coarse_s4_32 coarse_s4_33 VDD VDD VSS VSS gf180mcu_fd_sc_mcu7t5v0__inv_1
Xs_4_34 coarse_s4_33 coarse_s4_34 VDD VDD VSS VSS gf180mcu_fd_sc_mcu7t5v0__inv_1
Xs_4_35 coarse_s4_34 coarse_s4_35 VDD VDD VSS VSS gf180mcu_fd_sc_mcu7t5v0__inv_1
Xs_4_36 coarse_s4_35 coarse_s4_36 VDD VDD VSS VSS gf180mcu_fd_sc_mcu7t5v0__inv_1
Xs_4_37 coarse_s4_36 coarse_s4_37 VDD VDD VSS VSS gf180mcu_fd_sc_mcu7t5v0__inv_1
Xs_4_38 coarse_s4_37 coarse_s4_38 VDD VDD VSS VSS gf180mcu_fd_sc_mcu7t5v0__inv_1
Xs_4_39 coarse_s4_38 coarse_s4_39 VDD VDD VSS VSS gf180mcu_fd_sc_mcu7t5v0__inv_1
Xs_4_40 coarse_s4_39 coarse_s4_40 VDD VDD VSS VSS gf180mcu_fd_sc_mcu7t5v0__inv_1
Xs_4_41 coarse_s4_40 coarse_s4_41 VDD VDD VSS VSS gf180mcu_fd_sc_mcu7t5v0__inv_1
Xs_4_42 coarse_s4_41 coarse_s4_42 VDD VDD VSS VSS gf180mcu_fd_sc_mcu7t5v0__inv_1
Xs_4_43 coarse_s4_42 coarse_s4_43 VDD VDD VSS VSS gf180mcu_fd_sc_mcu7t5v0__inv_1
Xs_4_44 coarse_s4_43 coarse_s4_44 VDD VDD VSS VSS gf180mcu_fd_sc_mcu7t5v0__inv_1
Xs_4_45 coarse_s4_44 coarse_s4_45 VDD VDD VSS VSS gf180mcu_fd_sc_mcu7t5v0__inv_1
Xs_4_46 coarse_s4_45 coarse_s4_46 VDD VDD VSS VSS gf180mcu_fd_sc_mcu7t5v0__inv_1
Xs_4_47 coarse_s4_46 coarse_s4_47 VDD VDD VSS VSS gf180mcu_fd_sc_mcu7t5v0__inv_1
Xs_4_48 coarse_s4_47 coarse_s4_48 VDD VDD VSS VSS gf180mcu_fd_sc_mcu7t5v0__inv_1
Xs_4_49 coarse_s4_48 coarse_s4_49 VDD VDD VSS VSS gf180mcu_fd_sc_mcu7t5v0__inv_1
Xs_4_50 coarse_s4_49 coarse_s4_50 VDD VDD VSS VSS gf180mcu_fd_sc_mcu7t5v0__inv_1
Xs_4_51 coarse_s4_50 coarse_s4_51 VDD VDD VSS VSS gf180mcu_fd_sc_mcu7t5v0__inv_1
Xs_4_52 coarse_s4_51 coarse_s4_52 VDD VDD VSS VSS gf180mcu_fd_sc_mcu7t5v0__inv_1
Xs_4_53 coarse_s4_52 coarse_s4_53 VDD VDD VSS VSS gf180mcu_fd_sc_mcu7t5v0__inv_1
Xs_4_54 coarse_s4_53 coarse_s4_54 VDD VDD VSS VSS gf180mcu_fd_sc_mcu7t5v0__inv_1
Xs_4_55 coarse_s4_54 coarse_s4_55 VDD VDD VSS VSS gf180mcu_fd_sc_mcu7t5v0__inv_1
Xs_4_56 coarse_s4_55 coarse_s4_56 VDD VDD VSS VSS gf180mcu_fd_sc_mcu7t5v0__inv_1
Xs_4_57 coarse_s4_56 coarse_s4_57 VDD VDD VSS VSS gf180mcu_fd_sc_mcu7t5v0__inv_1
Xs_4_58 coarse_s4_57 coarse_s4_58 VDD VDD VSS VSS gf180mcu_fd_sc_mcu7t5v0__inv_1
Xs_4_59 coarse_s4_58 coarse_s4_59 VDD VDD VSS VSS gf180mcu_fd_sc_mcu7t5v0__inv_1
Xs_4_60 coarse_s4_59 coarse_s4_60 VDD VDD VSS VSS gf180mcu_fd_sc_mcu7t5v0__inv_1
Xs_4_61 coarse_s4_60 coarse_s4_61 VDD VDD VSS VSS gf180mcu_fd_sc_mcu7t5v0__inv_1
Xs_4_62 coarse_s4_61 coarse_s4_62 VDD VDD VSS VSS gf180mcu_fd_sc_mcu7t5v0__inv_1
Xs_4_63 coarse_s4_62 coarse_s4_63 VDD VDD VSS VSS gf180mcu_fd_sc_mcu7t5v0__inv_1
Xs_4_64 coarse_s4_63 coarse_s4_64 VDD VDD VSS VSS gf180mcu_fd_sc_mcu7t5v0__inv_1
Xs_4_65 coarse_s4_64 coarse_s4_65 VDD VDD VSS VSS gf180mcu_fd_sc_mcu7t5v0__inv_1
Xs_4_66 coarse_s4_65 coarse_s4_66 VDD VDD VSS VSS gf180mcu_fd_sc_mcu7t5v0__inv_1
Xs_4_67 coarse_s4_66 coarse_s4_67 VDD VDD VSS VSS gf180mcu_fd_sc_mcu7t5v0__inv_1
Xs_4_68 coarse_s4_67 coarse_s4_68 VDD VDD VSS VSS gf180mcu_fd_sc_mcu7t5v0__inv_1
Xs_4_69 coarse_s4_68 coarse_s4_69 VDD VDD VSS VSS gf180mcu_fd_sc_mcu7t5v0__inv_1
Xs_4_70 coarse_s4_69 coarse_s4_70 VDD VDD VSS VSS gf180mcu_fd_sc_mcu7t5v0__inv_1
Xs_4_71 coarse_s4_70 coarse_s4_71 VDD VDD VSS VSS gf180mcu_fd_sc_mcu7t5v0__inv_1
Xs_4_72 coarse_s4_71 coarse_s4_72 VDD VDD VSS VSS gf180mcu_fd_sc_mcu7t5v0__inv_1
Xs_4_73 coarse_s4_72 coarse_s4_73 VDD VDD VSS VSS gf180mcu_fd_sc_mcu7t5v0__inv_1
Xs_4_74 coarse_s4_73 coarse_s4_74 VDD VDD VSS VSS gf180mcu_fd_sc_mcu7t5v0__inv_1
Xs_4_75 coarse_s4_74 coarse_s4_75 VDD VDD VSS VSS gf180mcu_fd_sc_mcu7t5v0__inv_1
Xs_4_76 coarse_s4_75 coarse_s4_76 VDD VDD VSS VSS gf180mcu_fd_sc_mcu7t5v0__inv_1
Xs_4_77 coarse_s4_76 coarse_s4_77 VDD VDD VSS VSS gf180mcu_fd_sc_mcu7t5v0__inv_1
Xs_4_78 coarse_s4_77 coarse_s4_78 VDD VDD VSS VSS gf180mcu_fd_sc_mcu7t5v0__inv_1
Xs_4_79 coarse_s4_78 coarse_s4_79 VDD VDD VSS VSS gf180mcu_fd_sc_mcu7t5v0__inv_1
Xs_4_80 coarse_s4_79 coarse_s4_80 VDD VDD VSS VSS gf180mcu_fd_sc_mcu7t5v0__inv_1
Xs_4_81 coarse_s4_80 coarse_s4_81 VDD VDD VSS VSS gf180mcu_fd_sc_mcu7t5v0__inv_1
Xs_4_82 coarse_s4_81 coarse_s4_82 VDD VDD VSS VSS gf180mcu_fd_sc_mcu7t5v0__inv_1
Xs_4_83 coarse_s4_82 coarse_s4_83 VDD VDD VSS VSS gf180mcu_fd_sc_mcu7t5v0__inv_1
Xs_4_84 coarse_s4_83 coarse_s4_84 VDD VDD VSS VSS gf180mcu_fd_sc_mcu7t5v0__inv_1
Xs_4_85 coarse_s4_84 coarse_s4_85 VDD VDD VSS VSS gf180mcu_fd_sc_mcu7t5v0__inv_1
Xs_4_86 coarse_s4_85 coarse_s4_86 VDD VDD VSS VSS gf180mcu_fd_sc_mcu7t5v0__inv_1
Xs_4_87 coarse_s4_86 coarse_s4_87 VDD VDD VSS VSS gf180mcu_fd_sc_mcu7t5v0__inv_1
Xs_4_88 coarse_s4_87 coarse_s4_88 VDD VDD VSS VSS gf180mcu_fd_sc_mcu7t5v0__inv_1
Xs_4_89 coarse_s4_88 coarse_tap_s4 VDD VDD VSS VSS gf180mcu_fd_sc_mcu7t5v0__inv_1
Xs_5_0 coarse_tap_s4 coarse_s5_0 VDD VDD VSS VSS gf180mcu_fd_sc_mcu7t5v0__inv_1
Xs_5_1 coarse_s5_0 coarse_s5_1 VDD VDD VSS VSS gf180mcu_fd_sc_mcu7t5v0__inv_1
Xs_5_2 coarse_s5_1 coarse_s5_2 VDD VDD VSS VSS gf180mcu_fd_sc_mcu7t5v0__inv_1
Xs_5_3 coarse_s5_2 coarse_s5_3 VDD VDD VSS VSS gf180mcu_fd_sc_mcu7t5v0__inv_1
Xs_5_4 coarse_s5_3 coarse_s5_4 VDD VDD VSS VSS gf180mcu_fd_sc_mcu7t5v0__inv_1
Xs_5_5 coarse_s5_4 coarse_s5_5 VDD VDD VSS VSS gf180mcu_fd_sc_mcu7t5v0__inv_1
Xs_5_6 coarse_s5_5 coarse_s5_6 VDD VDD VSS VSS gf180mcu_fd_sc_mcu7t5v0__inv_1
Xs_5_7 coarse_s5_6 coarse_s5_7 VDD VDD VSS VSS gf180mcu_fd_sc_mcu7t5v0__inv_1
Xs_5_8 coarse_s5_7 coarse_s5_8 VDD VDD VSS VSS gf180mcu_fd_sc_mcu7t5v0__inv_1
Xs_5_9 coarse_s5_8 coarse_s5_9 VDD VDD VSS VSS gf180mcu_fd_sc_mcu7t5v0__inv_1
Xs_5_10 coarse_s5_9 coarse_s5_10 VDD VDD VSS VSS gf180mcu_fd_sc_mcu7t5v0__inv_1
Xs_5_11 coarse_s5_10 coarse_s5_11 VDD VDD VSS VSS gf180mcu_fd_sc_mcu7t5v0__inv_1
Xs_5_12 coarse_s5_11 coarse_s5_12 VDD VDD VSS VSS gf180mcu_fd_sc_mcu7t5v0__inv_1
Xs_5_13 coarse_s5_12 coarse_s5_13 VDD VDD VSS VSS gf180mcu_fd_sc_mcu7t5v0__inv_1
Xs_5_14 coarse_s5_13 coarse_s5_14 VDD VDD VSS VSS gf180mcu_fd_sc_mcu7t5v0__inv_1
Xs_5_15 coarse_s5_14 coarse_s5_15 VDD VDD VSS VSS gf180mcu_fd_sc_mcu7t5v0__inv_1
Xs_5_16 coarse_s5_15 coarse_s5_16 VDD VDD VSS VSS gf180mcu_fd_sc_mcu7t5v0__inv_1
Xs_5_17 coarse_s5_16 coarse_s5_17 VDD VDD VSS VSS gf180mcu_fd_sc_mcu7t5v0__inv_1
Xs_5_18 coarse_s5_17 coarse_s5_18 VDD VDD VSS VSS gf180mcu_fd_sc_mcu7t5v0__inv_1
Xs_5_19 coarse_s5_18 coarse_s5_19 VDD VDD VSS VSS gf180mcu_fd_sc_mcu7t5v0__inv_1
Xs_5_20 coarse_s5_19 coarse_s5_20 VDD VDD VSS VSS gf180mcu_fd_sc_mcu7t5v0__inv_1
Xs_5_21 coarse_s5_20 coarse_s5_21 VDD VDD VSS VSS gf180mcu_fd_sc_mcu7t5v0__inv_1
Xs_5_22 coarse_s5_21 coarse_s5_22 VDD VDD VSS VSS gf180mcu_fd_sc_mcu7t5v0__inv_1
Xs_5_23 coarse_s5_22 coarse_s5_23 VDD VDD VSS VSS gf180mcu_fd_sc_mcu7t5v0__inv_1
Xs_5_24 coarse_s5_23 coarse_s5_24 VDD VDD VSS VSS gf180mcu_fd_sc_mcu7t5v0__inv_1
Xs_5_25 coarse_s5_24 coarse_s5_25 VDD VDD VSS VSS gf180mcu_fd_sc_mcu7t5v0__inv_1
Xs_5_26 coarse_s5_25 coarse_s5_26 VDD VDD VSS VSS gf180mcu_fd_sc_mcu7t5v0__inv_1
Xs_5_27 coarse_s5_26 coarse_s5_27 VDD VDD VSS VSS gf180mcu_fd_sc_mcu7t5v0__inv_1
Xs_5_28 coarse_s5_27 coarse_s5_28 VDD VDD VSS VSS gf180mcu_fd_sc_mcu7t5v0__inv_1
Xs_5_29 coarse_s5_28 coarse_s5_29 VDD VDD VSS VSS gf180mcu_fd_sc_mcu7t5v0__inv_1
Xs_5_30 coarse_s5_29 coarse_s5_30 VDD VDD VSS VSS gf180mcu_fd_sc_mcu7t5v0__inv_1
Xs_5_31 coarse_s5_30 coarse_s5_31 VDD VDD VSS VSS gf180mcu_fd_sc_mcu7t5v0__inv_1
Xs_5_32 coarse_s5_31 coarse_s5_32 VDD VDD VSS VSS gf180mcu_fd_sc_mcu7t5v0__inv_1
Xs_5_33 coarse_s5_32 coarse_s5_33 VDD VDD VSS VSS gf180mcu_fd_sc_mcu7t5v0__inv_1
Xs_5_34 coarse_s5_33 coarse_s5_34 VDD VDD VSS VSS gf180mcu_fd_sc_mcu7t5v0__inv_1
Xs_5_35 coarse_s5_34 coarse_s5_35 VDD VDD VSS VSS gf180mcu_fd_sc_mcu7t5v0__inv_1
Xs_5_36 coarse_s5_35 coarse_s5_36 VDD VDD VSS VSS gf180mcu_fd_sc_mcu7t5v0__inv_1
Xs_5_37 coarse_s5_36 coarse_s5_37 VDD VDD VSS VSS gf180mcu_fd_sc_mcu7t5v0__inv_1
Xs_5_38 coarse_s5_37 coarse_s5_38 VDD VDD VSS VSS gf180mcu_fd_sc_mcu7t5v0__inv_1
Xs_5_39 coarse_s5_38 coarse_s5_39 VDD VDD VSS VSS gf180mcu_fd_sc_mcu7t5v0__inv_1
Xs_5_40 coarse_s5_39 coarse_s5_40 VDD VDD VSS VSS gf180mcu_fd_sc_mcu7t5v0__inv_1
Xs_5_41 coarse_s5_40 coarse_s5_41 VDD VDD VSS VSS gf180mcu_fd_sc_mcu7t5v0__inv_1
Xs_5_42 coarse_s5_41 coarse_s5_42 VDD VDD VSS VSS gf180mcu_fd_sc_mcu7t5v0__inv_1
Xs_5_43 coarse_s5_42 coarse_s5_43 VDD VDD VSS VSS gf180mcu_fd_sc_mcu7t5v0__inv_1
Xs_5_44 coarse_s5_43 coarse_s5_44 VDD VDD VSS VSS gf180mcu_fd_sc_mcu7t5v0__inv_1
Xs_5_45 coarse_s5_44 coarse_s5_45 VDD VDD VSS VSS gf180mcu_fd_sc_mcu7t5v0__inv_1
Xs_5_46 coarse_s5_45 coarse_s5_46 VDD VDD VSS VSS gf180mcu_fd_sc_mcu7t5v0__inv_1
Xs_5_47 coarse_s5_46 coarse_s5_47 VDD VDD VSS VSS gf180mcu_fd_sc_mcu7t5v0__inv_1
Xs_5_48 coarse_s5_47 coarse_s5_48 VDD VDD VSS VSS gf180mcu_fd_sc_mcu7t5v0__inv_1
Xs_5_49 coarse_s5_48 coarse_s5_49 VDD VDD VSS VSS gf180mcu_fd_sc_mcu7t5v0__inv_1
Xs_5_50 coarse_s5_49 coarse_s5_50 VDD VDD VSS VSS gf180mcu_fd_sc_mcu7t5v0__inv_1
Xs_5_51 coarse_s5_50 coarse_s5_51 VDD VDD VSS VSS gf180mcu_fd_sc_mcu7t5v0__inv_1
Xs_5_52 coarse_s5_51 coarse_s5_52 VDD VDD VSS VSS gf180mcu_fd_sc_mcu7t5v0__inv_1
Xs_5_53 coarse_s5_52 coarse_s5_53 VDD VDD VSS VSS gf180mcu_fd_sc_mcu7t5v0__inv_1
Xs_5_54 coarse_s5_53 coarse_s5_54 VDD VDD VSS VSS gf180mcu_fd_sc_mcu7t5v0__inv_1
Xs_5_55 coarse_s5_54 coarse_s5_55 VDD VDD VSS VSS gf180mcu_fd_sc_mcu7t5v0__inv_1
Xs_5_56 coarse_s5_55 coarse_s5_56 VDD VDD VSS VSS gf180mcu_fd_sc_mcu7t5v0__inv_1
Xs_5_57 coarse_s5_56 coarse_s5_57 VDD VDD VSS VSS gf180mcu_fd_sc_mcu7t5v0__inv_1
Xs_5_58 coarse_s5_57 coarse_s5_58 VDD VDD VSS VSS gf180mcu_fd_sc_mcu7t5v0__inv_1
Xs_5_59 coarse_s5_58 coarse_s5_59 VDD VDD VSS VSS gf180mcu_fd_sc_mcu7t5v0__inv_1
Xs_5_60 coarse_s5_59 coarse_s5_60 VDD VDD VSS VSS gf180mcu_fd_sc_mcu7t5v0__inv_1
Xs_5_61 coarse_s5_60 coarse_s5_61 VDD VDD VSS VSS gf180mcu_fd_sc_mcu7t5v0__inv_1
Xs_5_62 coarse_s5_61 coarse_s5_62 VDD VDD VSS VSS gf180mcu_fd_sc_mcu7t5v0__inv_1
Xs_5_63 coarse_s5_62 coarse_s5_63 VDD VDD VSS VSS gf180mcu_fd_sc_mcu7t5v0__inv_1
Xs_5_64 coarse_s5_63 coarse_s5_64 VDD VDD VSS VSS gf180mcu_fd_sc_mcu7t5v0__inv_1
Xs_5_65 coarse_s5_64 coarse_s5_65 VDD VDD VSS VSS gf180mcu_fd_sc_mcu7t5v0__inv_1
Xs_5_66 coarse_s5_65 coarse_s5_66 VDD VDD VSS VSS gf180mcu_fd_sc_mcu7t5v0__inv_1
Xs_5_67 coarse_s5_66 coarse_s5_67 VDD VDD VSS VSS gf180mcu_fd_sc_mcu7t5v0__inv_1
Xs_5_68 coarse_s5_67 coarse_s5_68 VDD VDD VSS VSS gf180mcu_fd_sc_mcu7t5v0__inv_1
Xs_5_69 coarse_s5_68 coarse_s5_69 VDD VDD VSS VSS gf180mcu_fd_sc_mcu7t5v0__inv_1
Xs_5_70 coarse_s5_69 coarse_s5_70 VDD VDD VSS VSS gf180mcu_fd_sc_mcu7t5v0__inv_1
Xs_5_71 coarse_s5_70 coarse_s5_71 VDD VDD VSS VSS gf180mcu_fd_sc_mcu7t5v0__inv_1
Xs_5_72 coarse_s5_71 coarse_s5_72 VDD VDD VSS VSS gf180mcu_fd_sc_mcu7t5v0__inv_1
Xs_5_73 coarse_s5_72 coarse_s5_73 VDD VDD VSS VSS gf180mcu_fd_sc_mcu7t5v0__inv_1
Xs_5_74 coarse_s5_73 coarse_s5_74 VDD VDD VSS VSS gf180mcu_fd_sc_mcu7t5v0__inv_1
Xs_5_75 coarse_s5_74 coarse_s5_75 VDD VDD VSS VSS gf180mcu_fd_sc_mcu7t5v0__inv_1
Xs_5_76 coarse_s5_75 coarse_s5_76 VDD VDD VSS VSS gf180mcu_fd_sc_mcu7t5v0__inv_1
Xs_5_77 coarse_s5_76 coarse_s5_77 VDD VDD VSS VSS gf180mcu_fd_sc_mcu7t5v0__inv_1
Xs_5_78 coarse_s5_77 coarse_s5_78 VDD VDD VSS VSS gf180mcu_fd_sc_mcu7t5v0__inv_1
Xs_5_79 coarse_s5_78 coarse_s5_79 VDD VDD VSS VSS gf180mcu_fd_sc_mcu7t5v0__inv_1
Xs_5_80 coarse_s5_79 coarse_s5_80 VDD VDD VSS VSS gf180mcu_fd_sc_mcu7t5v0__inv_1
Xs_5_81 coarse_s5_80 coarse_s5_81 VDD VDD VSS VSS gf180mcu_fd_sc_mcu7t5v0__inv_1
Xs_5_82 coarse_s5_81 coarse_s5_82 VDD VDD VSS VSS gf180mcu_fd_sc_mcu7t5v0__inv_1
Xs_5_83 coarse_s5_82 coarse_s5_83 VDD VDD VSS VSS gf180mcu_fd_sc_mcu7t5v0__inv_1
Xs_5_84 coarse_s5_83 coarse_s5_84 VDD VDD VSS VSS gf180mcu_fd_sc_mcu7t5v0__inv_1
Xs_5_85 coarse_s5_84 coarse_s5_85 VDD VDD VSS VSS gf180mcu_fd_sc_mcu7t5v0__inv_1
Xs_5_86 coarse_s5_85 coarse_s5_86 VDD VDD VSS VSS gf180mcu_fd_sc_mcu7t5v0__inv_1
Xs_5_87 coarse_s5_86 coarse_s5_87 VDD VDD VSS VSS gf180mcu_fd_sc_mcu7t5v0__inv_1
Xs_5_88 coarse_s5_87 coarse_s5_88 VDD VDD VSS VSS gf180mcu_fd_sc_mcu7t5v0__inv_1
Xs_5_89 coarse_s5_88 coarse_tap_s5 VDD VDD VSS VSS gf180mcu_fd_sc_mcu7t5v0__inv_1
Xs_6_0 coarse_tap_s5 coarse_s6_0 VDD VDD VSS VSS gf180mcu_fd_sc_mcu7t5v0__inv_1
Xs_6_1 coarse_s6_0 coarse_s6_1 VDD VDD VSS VSS gf180mcu_fd_sc_mcu7t5v0__inv_1
Xs_6_2 coarse_s6_1 coarse_s6_2 VDD VDD VSS VSS gf180mcu_fd_sc_mcu7t5v0__inv_1
Xs_6_3 coarse_s6_2 coarse_s6_3 VDD VDD VSS VSS gf180mcu_fd_sc_mcu7t5v0__inv_1
Xs_6_4 coarse_s6_3 coarse_s6_4 VDD VDD VSS VSS gf180mcu_fd_sc_mcu7t5v0__inv_1
Xs_6_5 coarse_s6_4 coarse_s6_5 VDD VDD VSS VSS gf180mcu_fd_sc_mcu7t5v0__inv_1
Xs_6_6 coarse_s6_5 coarse_s6_6 VDD VDD VSS VSS gf180mcu_fd_sc_mcu7t5v0__inv_1
Xs_6_7 coarse_s6_6 coarse_s6_7 VDD VDD VSS VSS gf180mcu_fd_sc_mcu7t5v0__inv_1
Xs_6_8 coarse_s6_7 coarse_s6_8 VDD VDD VSS VSS gf180mcu_fd_sc_mcu7t5v0__inv_1
Xs_6_9 coarse_s6_8 coarse_s6_9 VDD VDD VSS VSS gf180mcu_fd_sc_mcu7t5v0__inv_1
Xs_6_10 coarse_s6_9 coarse_s6_10 VDD VDD VSS VSS gf180mcu_fd_sc_mcu7t5v0__inv_1
Xs_6_11 coarse_s6_10 coarse_s6_11 VDD VDD VSS VSS gf180mcu_fd_sc_mcu7t5v0__inv_1
Xs_6_12 coarse_s6_11 coarse_s6_12 VDD VDD VSS VSS gf180mcu_fd_sc_mcu7t5v0__inv_1
Xs_6_13 coarse_s6_12 coarse_s6_13 VDD VDD VSS VSS gf180mcu_fd_sc_mcu7t5v0__inv_1
Xs_6_14 coarse_s6_13 coarse_s6_14 VDD VDD VSS VSS gf180mcu_fd_sc_mcu7t5v0__inv_1
Xs_6_15 coarse_s6_14 coarse_s6_15 VDD VDD VSS VSS gf180mcu_fd_sc_mcu7t5v0__inv_1
Xs_6_16 coarse_s6_15 coarse_s6_16 VDD VDD VSS VSS gf180mcu_fd_sc_mcu7t5v0__inv_1
Xs_6_17 coarse_s6_16 coarse_s6_17 VDD VDD VSS VSS gf180mcu_fd_sc_mcu7t5v0__inv_1
Xs_6_18 coarse_s6_17 coarse_s6_18 VDD VDD VSS VSS gf180mcu_fd_sc_mcu7t5v0__inv_1
Xs_6_19 coarse_s6_18 coarse_s6_19 VDD VDD VSS VSS gf180mcu_fd_sc_mcu7t5v0__inv_1
Xs_6_20 coarse_s6_19 coarse_s6_20 VDD VDD VSS VSS gf180mcu_fd_sc_mcu7t5v0__inv_1
Xs_6_21 coarse_s6_20 coarse_s6_21 VDD VDD VSS VSS gf180mcu_fd_sc_mcu7t5v0__inv_1
Xs_6_22 coarse_s6_21 coarse_s6_22 VDD VDD VSS VSS gf180mcu_fd_sc_mcu7t5v0__inv_1
Xs_6_23 coarse_s6_22 coarse_s6_23 VDD VDD VSS VSS gf180mcu_fd_sc_mcu7t5v0__inv_1
Xs_6_24 coarse_s6_23 coarse_s6_24 VDD VDD VSS VSS gf180mcu_fd_sc_mcu7t5v0__inv_1
Xs_6_25 coarse_s6_24 coarse_s6_25 VDD VDD VSS VSS gf180mcu_fd_sc_mcu7t5v0__inv_1
Xs_6_26 coarse_s6_25 coarse_s6_26 VDD VDD VSS VSS gf180mcu_fd_sc_mcu7t5v0__inv_1
Xs_6_27 coarse_s6_26 coarse_s6_27 VDD VDD VSS VSS gf180mcu_fd_sc_mcu7t5v0__inv_1
Xs_6_28 coarse_s6_27 coarse_s6_28 VDD VDD VSS VSS gf180mcu_fd_sc_mcu7t5v0__inv_1
Xs_6_29 coarse_s6_28 coarse_s6_29 VDD VDD VSS VSS gf180mcu_fd_sc_mcu7t5v0__inv_1
Xs_6_30 coarse_s6_29 coarse_s6_30 VDD VDD VSS VSS gf180mcu_fd_sc_mcu7t5v0__inv_1
Xs_6_31 coarse_s6_30 coarse_s6_31 VDD VDD VSS VSS gf180mcu_fd_sc_mcu7t5v0__inv_1
Xs_6_32 coarse_s6_31 coarse_s6_32 VDD VDD VSS VSS gf180mcu_fd_sc_mcu7t5v0__inv_1
Xs_6_33 coarse_s6_32 coarse_s6_33 VDD VDD VSS VSS gf180mcu_fd_sc_mcu7t5v0__inv_1
Xs_6_34 coarse_s6_33 coarse_s6_34 VDD VDD VSS VSS gf180mcu_fd_sc_mcu7t5v0__inv_1
Xs_6_35 coarse_s6_34 coarse_s6_35 VDD VDD VSS VSS gf180mcu_fd_sc_mcu7t5v0__inv_1
Xs_6_36 coarse_s6_35 coarse_s6_36 VDD VDD VSS VSS gf180mcu_fd_sc_mcu7t5v0__inv_1
Xs_6_37 coarse_s6_36 coarse_s6_37 VDD VDD VSS VSS gf180mcu_fd_sc_mcu7t5v0__inv_1
Xs_6_38 coarse_s6_37 coarse_s6_38 VDD VDD VSS VSS gf180mcu_fd_sc_mcu7t5v0__inv_1
Xs_6_39 coarse_s6_38 coarse_s6_39 VDD VDD VSS VSS gf180mcu_fd_sc_mcu7t5v0__inv_1
Xs_6_40 coarse_s6_39 coarse_s6_40 VDD VDD VSS VSS gf180mcu_fd_sc_mcu7t5v0__inv_1
Xs_6_41 coarse_s6_40 coarse_s6_41 VDD VDD VSS VSS gf180mcu_fd_sc_mcu7t5v0__inv_1
Xs_6_42 coarse_s6_41 coarse_s6_42 VDD VDD VSS VSS gf180mcu_fd_sc_mcu7t5v0__inv_1
Xs_6_43 coarse_s6_42 coarse_s6_43 VDD VDD VSS VSS gf180mcu_fd_sc_mcu7t5v0__inv_1
Xs_6_44 coarse_s6_43 coarse_s6_44 VDD VDD VSS VSS gf180mcu_fd_sc_mcu7t5v0__inv_1
Xs_6_45 coarse_s6_44 coarse_s6_45 VDD VDD VSS VSS gf180mcu_fd_sc_mcu7t5v0__inv_1
Xs_6_46 coarse_s6_45 coarse_s6_46 VDD VDD VSS VSS gf180mcu_fd_sc_mcu7t5v0__inv_1
Xs_6_47 coarse_s6_46 coarse_s6_47 VDD VDD VSS VSS gf180mcu_fd_sc_mcu7t5v0__inv_1
Xs_6_48 coarse_s6_47 coarse_s6_48 VDD VDD VSS VSS gf180mcu_fd_sc_mcu7t5v0__inv_1
Xs_6_49 coarse_s6_48 coarse_s6_49 VDD VDD VSS VSS gf180mcu_fd_sc_mcu7t5v0__inv_1
Xs_6_50 coarse_s6_49 coarse_s6_50 VDD VDD VSS VSS gf180mcu_fd_sc_mcu7t5v0__inv_1
Xs_6_51 coarse_s6_50 coarse_s6_51 VDD VDD VSS VSS gf180mcu_fd_sc_mcu7t5v0__inv_1
Xs_6_52 coarse_s6_51 coarse_s6_52 VDD VDD VSS VSS gf180mcu_fd_sc_mcu7t5v0__inv_1
Xs_6_53 coarse_s6_52 coarse_s6_53 VDD VDD VSS VSS gf180mcu_fd_sc_mcu7t5v0__inv_1
Xs_6_54 coarse_s6_53 coarse_s6_54 VDD VDD VSS VSS gf180mcu_fd_sc_mcu7t5v0__inv_1
Xs_6_55 coarse_s6_54 coarse_s6_55 VDD VDD VSS VSS gf180mcu_fd_sc_mcu7t5v0__inv_1
Xs_6_56 coarse_s6_55 coarse_s6_56 VDD VDD VSS VSS gf180mcu_fd_sc_mcu7t5v0__inv_1
Xs_6_57 coarse_s6_56 coarse_s6_57 VDD VDD VSS VSS gf180mcu_fd_sc_mcu7t5v0__inv_1
Xs_6_58 coarse_s6_57 coarse_s6_58 VDD VDD VSS VSS gf180mcu_fd_sc_mcu7t5v0__inv_1
Xs_6_59 coarse_s6_58 coarse_s6_59 VDD VDD VSS VSS gf180mcu_fd_sc_mcu7t5v0__inv_1
Xs_6_60 coarse_s6_59 coarse_s6_60 VDD VDD VSS VSS gf180mcu_fd_sc_mcu7t5v0__inv_1
Xs_6_61 coarse_s6_60 coarse_s6_61 VDD VDD VSS VSS gf180mcu_fd_sc_mcu7t5v0__inv_1
Xs_6_62 coarse_s6_61 coarse_s6_62 VDD VDD VSS VSS gf180mcu_fd_sc_mcu7t5v0__inv_1
Xs_6_63 coarse_s6_62 coarse_s6_63 VDD VDD VSS VSS gf180mcu_fd_sc_mcu7t5v0__inv_1
Xs_6_64 coarse_s6_63 coarse_s6_64 VDD VDD VSS VSS gf180mcu_fd_sc_mcu7t5v0__inv_1
Xs_6_65 coarse_s6_64 coarse_s6_65 VDD VDD VSS VSS gf180mcu_fd_sc_mcu7t5v0__inv_1
Xs_6_66 coarse_s6_65 coarse_s6_66 VDD VDD VSS VSS gf180mcu_fd_sc_mcu7t5v0__inv_1
Xs_6_67 coarse_s6_66 coarse_s6_67 VDD VDD VSS VSS gf180mcu_fd_sc_mcu7t5v0__inv_1
Xs_6_68 coarse_s6_67 coarse_s6_68 VDD VDD VSS VSS gf180mcu_fd_sc_mcu7t5v0__inv_1
Xs_6_69 coarse_s6_68 coarse_s6_69 VDD VDD VSS VSS gf180mcu_fd_sc_mcu7t5v0__inv_1
Xs_6_70 coarse_s6_69 coarse_s6_70 VDD VDD VSS VSS gf180mcu_fd_sc_mcu7t5v0__inv_1
Xs_6_71 coarse_s6_70 coarse_s6_71 VDD VDD VSS VSS gf180mcu_fd_sc_mcu7t5v0__inv_1
Xs_6_72 coarse_s6_71 coarse_s6_72 VDD VDD VSS VSS gf180mcu_fd_sc_mcu7t5v0__inv_1
Xs_6_73 coarse_s6_72 coarse_s6_73 VDD VDD VSS VSS gf180mcu_fd_sc_mcu7t5v0__inv_1
Xs_6_74 coarse_s6_73 coarse_s6_74 VDD VDD VSS VSS gf180mcu_fd_sc_mcu7t5v0__inv_1
Xs_6_75 coarse_s6_74 coarse_s6_75 VDD VDD VSS VSS gf180mcu_fd_sc_mcu7t5v0__inv_1
Xs_6_76 coarse_s6_75 coarse_s6_76 VDD VDD VSS VSS gf180mcu_fd_sc_mcu7t5v0__inv_1
Xs_6_77 coarse_s6_76 coarse_s6_77 VDD VDD VSS VSS gf180mcu_fd_sc_mcu7t5v0__inv_1
Xs_6_78 coarse_s6_77 coarse_s6_78 VDD VDD VSS VSS gf180mcu_fd_sc_mcu7t5v0__inv_1
Xs_6_79 coarse_s6_78 coarse_s6_79 VDD VDD VSS VSS gf180mcu_fd_sc_mcu7t5v0__inv_1
Xs_6_80 coarse_s6_79 coarse_s6_80 VDD VDD VSS VSS gf180mcu_fd_sc_mcu7t5v0__inv_1
Xs_6_81 coarse_s6_80 coarse_s6_81 VDD VDD VSS VSS gf180mcu_fd_sc_mcu7t5v0__inv_1
Xs_6_82 coarse_s6_81 coarse_s6_82 VDD VDD VSS VSS gf180mcu_fd_sc_mcu7t5v0__inv_1
Xs_6_83 coarse_s6_82 coarse_s6_83 VDD VDD VSS VSS gf180mcu_fd_sc_mcu7t5v0__inv_1
Xs_6_84 coarse_s6_83 coarse_s6_84 VDD VDD VSS VSS gf180mcu_fd_sc_mcu7t5v0__inv_1
Xs_6_85 coarse_s6_84 coarse_s6_85 VDD VDD VSS VSS gf180mcu_fd_sc_mcu7t5v0__inv_1
Xs_6_86 coarse_s6_85 coarse_s6_86 VDD VDD VSS VSS gf180mcu_fd_sc_mcu7t5v0__inv_1
Xs_6_87 coarse_s6_86 coarse_s6_87 VDD VDD VSS VSS gf180mcu_fd_sc_mcu7t5v0__inv_1
Xs_6_88 coarse_s6_87 coarse_s6_88 VDD VDD VSS VSS gf180mcu_fd_sc_mcu7t5v0__inv_1
Xs_6_89 coarse_s6_88 coarse_tap_s6 VDD VDD VSS VSS gf180mcu_fd_sc_mcu7t5v0__inv_1
Xs_7_0 coarse_tap_s6 coarse_s7_0 VDD VDD VSS VSS gf180mcu_fd_sc_mcu7t5v0__inv_1
Xs_7_1 coarse_s7_0 coarse_s7_1 VDD VDD VSS VSS gf180mcu_fd_sc_mcu7t5v0__inv_1
Xs_7_2 coarse_s7_1 coarse_s7_2 VDD VDD VSS VSS gf180mcu_fd_sc_mcu7t5v0__inv_1
Xs_7_3 coarse_s7_2 coarse_s7_3 VDD VDD VSS VSS gf180mcu_fd_sc_mcu7t5v0__inv_1
Xs_7_4 coarse_s7_3 coarse_s7_4 VDD VDD VSS VSS gf180mcu_fd_sc_mcu7t5v0__inv_1
Xs_7_5 coarse_s7_4 coarse_s7_5 VDD VDD VSS VSS gf180mcu_fd_sc_mcu7t5v0__inv_1
Xs_7_6 coarse_s7_5 coarse_s7_6 VDD VDD VSS VSS gf180mcu_fd_sc_mcu7t5v0__inv_1
Xs_7_7 coarse_s7_6 coarse_s7_7 VDD VDD VSS VSS gf180mcu_fd_sc_mcu7t5v0__inv_1
Xs_7_8 coarse_s7_7 coarse_s7_8 VDD VDD VSS VSS gf180mcu_fd_sc_mcu7t5v0__inv_1
Xs_7_9 coarse_s7_8 coarse_s7_9 VDD VDD VSS VSS gf180mcu_fd_sc_mcu7t5v0__inv_1
Xs_7_10 coarse_s7_9 coarse_s7_10 VDD VDD VSS VSS gf180mcu_fd_sc_mcu7t5v0__inv_1
Xs_7_11 coarse_s7_10 coarse_s7_11 VDD VDD VSS VSS gf180mcu_fd_sc_mcu7t5v0__inv_1
Xs_7_12 coarse_s7_11 coarse_s7_12 VDD VDD VSS VSS gf180mcu_fd_sc_mcu7t5v0__inv_1
Xs_7_13 coarse_s7_12 coarse_s7_13 VDD VDD VSS VSS gf180mcu_fd_sc_mcu7t5v0__inv_1
Xs_7_14 coarse_s7_13 coarse_s7_14 VDD VDD VSS VSS gf180mcu_fd_sc_mcu7t5v0__inv_1
Xs_7_15 coarse_s7_14 coarse_s7_15 VDD VDD VSS VSS gf180mcu_fd_sc_mcu7t5v0__inv_1
Xs_7_16 coarse_s7_15 coarse_s7_16 VDD VDD VSS VSS gf180mcu_fd_sc_mcu7t5v0__inv_1
Xs_7_17 coarse_s7_16 coarse_s7_17 VDD VDD VSS VSS gf180mcu_fd_sc_mcu7t5v0__inv_1
Xs_7_18 coarse_s7_17 coarse_s7_18 VDD VDD VSS VSS gf180mcu_fd_sc_mcu7t5v0__inv_1
Xs_7_19 coarse_s7_18 coarse_s7_19 VDD VDD VSS VSS gf180mcu_fd_sc_mcu7t5v0__inv_1
Xs_7_20 coarse_s7_19 coarse_s7_20 VDD VDD VSS VSS gf180mcu_fd_sc_mcu7t5v0__inv_1
Xs_7_21 coarse_s7_20 coarse_s7_21 VDD VDD VSS VSS gf180mcu_fd_sc_mcu7t5v0__inv_1
Xs_7_22 coarse_s7_21 coarse_s7_22 VDD VDD VSS VSS gf180mcu_fd_sc_mcu7t5v0__inv_1
Xs_7_23 coarse_s7_22 coarse_s7_23 VDD VDD VSS VSS gf180mcu_fd_sc_mcu7t5v0__inv_1
Xs_7_24 coarse_s7_23 coarse_s7_24 VDD VDD VSS VSS gf180mcu_fd_sc_mcu7t5v0__inv_1
Xs_7_25 coarse_s7_24 coarse_s7_25 VDD VDD VSS VSS gf180mcu_fd_sc_mcu7t5v0__inv_1
Xs_7_26 coarse_s7_25 coarse_s7_26 VDD VDD VSS VSS gf180mcu_fd_sc_mcu7t5v0__inv_1
Xs_7_27 coarse_s7_26 coarse_s7_27 VDD VDD VSS VSS gf180mcu_fd_sc_mcu7t5v0__inv_1
Xs_7_28 coarse_s7_27 coarse_s7_28 VDD VDD VSS VSS gf180mcu_fd_sc_mcu7t5v0__inv_1
Xs_7_29 coarse_s7_28 coarse_s7_29 VDD VDD VSS VSS gf180mcu_fd_sc_mcu7t5v0__inv_1
Xs_7_30 coarse_s7_29 coarse_s7_30 VDD VDD VSS VSS gf180mcu_fd_sc_mcu7t5v0__inv_1
Xs_7_31 coarse_s7_30 coarse_s7_31 VDD VDD VSS VSS gf180mcu_fd_sc_mcu7t5v0__inv_1
Xs_7_32 coarse_s7_31 coarse_s7_32 VDD VDD VSS VSS gf180mcu_fd_sc_mcu7t5v0__inv_1
Xs_7_33 coarse_s7_32 coarse_s7_33 VDD VDD VSS VSS gf180mcu_fd_sc_mcu7t5v0__inv_1
Xs_7_34 coarse_s7_33 coarse_s7_34 VDD VDD VSS VSS gf180mcu_fd_sc_mcu7t5v0__inv_1
Xs_7_35 coarse_s7_34 coarse_s7_35 VDD VDD VSS VSS gf180mcu_fd_sc_mcu7t5v0__inv_1
Xs_7_36 coarse_s7_35 coarse_s7_36 VDD VDD VSS VSS gf180mcu_fd_sc_mcu7t5v0__inv_1
Xs_7_37 coarse_s7_36 coarse_s7_37 VDD VDD VSS VSS gf180mcu_fd_sc_mcu7t5v0__inv_1
Xs_7_38 coarse_s7_37 coarse_s7_38 VDD VDD VSS VSS gf180mcu_fd_sc_mcu7t5v0__inv_1
Xs_7_39 coarse_s7_38 coarse_s7_39 VDD VDD VSS VSS gf180mcu_fd_sc_mcu7t5v0__inv_1
Xs_7_40 coarse_s7_39 coarse_s7_40 VDD VDD VSS VSS gf180mcu_fd_sc_mcu7t5v0__inv_1
Xs_7_41 coarse_s7_40 coarse_s7_41 VDD VDD VSS VSS gf180mcu_fd_sc_mcu7t5v0__inv_1
Xs_7_42 coarse_s7_41 coarse_s7_42 VDD VDD VSS VSS gf180mcu_fd_sc_mcu7t5v0__inv_1
Xs_7_43 coarse_s7_42 coarse_s7_43 VDD VDD VSS VSS gf180mcu_fd_sc_mcu7t5v0__inv_1
Xs_7_44 coarse_s7_43 coarse_s7_44 VDD VDD VSS VSS gf180mcu_fd_sc_mcu7t5v0__inv_1
Xs_7_45 coarse_s7_44 coarse_s7_45 VDD VDD VSS VSS gf180mcu_fd_sc_mcu7t5v0__inv_1
Xs_7_46 coarse_s7_45 coarse_s7_46 VDD VDD VSS VSS gf180mcu_fd_sc_mcu7t5v0__inv_1
Xs_7_47 coarse_s7_46 coarse_s7_47 VDD VDD VSS VSS gf180mcu_fd_sc_mcu7t5v0__inv_1
Xs_7_48 coarse_s7_47 coarse_s7_48 VDD VDD VSS VSS gf180mcu_fd_sc_mcu7t5v0__inv_1
Xs_7_49 coarse_s7_48 coarse_s7_49 VDD VDD VSS VSS gf180mcu_fd_sc_mcu7t5v0__inv_1
Xs_7_50 coarse_s7_49 coarse_s7_50 VDD VDD VSS VSS gf180mcu_fd_sc_mcu7t5v0__inv_1
Xs_7_51 coarse_s7_50 coarse_s7_51 VDD VDD VSS VSS gf180mcu_fd_sc_mcu7t5v0__inv_1
Xs_7_52 coarse_s7_51 coarse_s7_52 VDD VDD VSS VSS gf180mcu_fd_sc_mcu7t5v0__inv_1
Xs_7_53 coarse_s7_52 coarse_s7_53 VDD VDD VSS VSS gf180mcu_fd_sc_mcu7t5v0__inv_1
Xs_7_54 coarse_s7_53 coarse_s7_54 VDD VDD VSS VSS gf180mcu_fd_sc_mcu7t5v0__inv_1
Xs_7_55 coarse_s7_54 coarse_s7_55 VDD VDD VSS VSS gf180mcu_fd_sc_mcu7t5v0__inv_1
Xs_7_56 coarse_s7_55 coarse_s7_56 VDD VDD VSS VSS gf180mcu_fd_sc_mcu7t5v0__inv_1
Xs_7_57 coarse_s7_56 coarse_s7_57 VDD VDD VSS VSS gf180mcu_fd_sc_mcu7t5v0__inv_1
Xs_7_58 coarse_s7_57 coarse_s7_58 VDD VDD VSS VSS gf180mcu_fd_sc_mcu7t5v0__inv_1
Xs_7_59 coarse_s7_58 coarse_s7_59 VDD VDD VSS VSS gf180mcu_fd_sc_mcu7t5v0__inv_1
Xs_7_60 coarse_s7_59 coarse_s7_60 VDD VDD VSS VSS gf180mcu_fd_sc_mcu7t5v0__inv_1
Xs_7_61 coarse_s7_60 coarse_s7_61 VDD VDD VSS VSS gf180mcu_fd_sc_mcu7t5v0__inv_1
Xs_7_62 coarse_s7_61 coarse_s7_62 VDD VDD VSS VSS gf180mcu_fd_sc_mcu7t5v0__inv_1
Xs_7_63 coarse_s7_62 coarse_s7_63 VDD VDD VSS VSS gf180mcu_fd_sc_mcu7t5v0__inv_1
Xs_7_64 coarse_s7_63 coarse_s7_64 VDD VDD VSS VSS gf180mcu_fd_sc_mcu7t5v0__inv_1
Xs_7_65 coarse_s7_64 coarse_s7_65 VDD VDD VSS VSS gf180mcu_fd_sc_mcu7t5v0__inv_1
Xs_7_66 coarse_s7_65 coarse_s7_66 VDD VDD VSS VSS gf180mcu_fd_sc_mcu7t5v0__inv_1
Xs_7_67 coarse_s7_66 coarse_s7_67 VDD VDD VSS VSS gf180mcu_fd_sc_mcu7t5v0__inv_1
Xs_7_68 coarse_s7_67 coarse_s7_68 VDD VDD VSS VSS gf180mcu_fd_sc_mcu7t5v0__inv_1
Xs_7_69 coarse_s7_68 coarse_s7_69 VDD VDD VSS VSS gf180mcu_fd_sc_mcu7t5v0__inv_1
Xs_7_70 coarse_s7_69 coarse_s7_70 VDD VDD VSS VSS gf180mcu_fd_sc_mcu7t5v0__inv_1
Xs_7_71 coarse_s7_70 coarse_s7_71 VDD VDD VSS VSS gf180mcu_fd_sc_mcu7t5v0__inv_1
Xs_7_72 coarse_s7_71 coarse_s7_72 VDD VDD VSS VSS gf180mcu_fd_sc_mcu7t5v0__inv_1
Xs_7_73 coarse_s7_72 coarse_s7_73 VDD VDD VSS VSS gf180mcu_fd_sc_mcu7t5v0__inv_1
Xs_7_74 coarse_s7_73 coarse_s7_74 VDD VDD VSS VSS gf180mcu_fd_sc_mcu7t5v0__inv_1
Xs_7_75 coarse_s7_74 coarse_s7_75 VDD VDD VSS VSS gf180mcu_fd_sc_mcu7t5v0__inv_1
Xs_7_76 coarse_s7_75 coarse_s7_76 VDD VDD VSS VSS gf180mcu_fd_sc_mcu7t5v0__inv_1
Xs_7_77 coarse_s7_76 coarse_s7_77 VDD VDD VSS VSS gf180mcu_fd_sc_mcu7t5v0__inv_1
Xs_7_78 coarse_s7_77 coarse_s7_78 VDD VDD VSS VSS gf180mcu_fd_sc_mcu7t5v0__inv_1
Xs_7_79 coarse_s7_78 coarse_s7_79 VDD VDD VSS VSS gf180mcu_fd_sc_mcu7t5v0__inv_1
Xs_7_80 coarse_s7_79 coarse_s7_80 VDD VDD VSS VSS gf180mcu_fd_sc_mcu7t5v0__inv_1
Xs_7_81 coarse_s7_80 coarse_s7_81 VDD VDD VSS VSS gf180mcu_fd_sc_mcu7t5v0__inv_1
Xs_7_82 coarse_s7_81 coarse_s7_82 VDD VDD VSS VSS gf180mcu_fd_sc_mcu7t5v0__inv_1
Xs_7_83 coarse_s7_82 coarse_s7_83 VDD VDD VSS VSS gf180mcu_fd_sc_mcu7t5v0__inv_1
Xs_7_84 coarse_s7_83 coarse_s7_84 VDD VDD VSS VSS gf180mcu_fd_sc_mcu7t5v0__inv_1
Xs_7_85 coarse_s7_84 coarse_s7_85 VDD VDD VSS VSS gf180mcu_fd_sc_mcu7t5v0__inv_1
Xs_7_86 coarse_s7_85 coarse_s7_86 VDD VDD VSS VSS gf180mcu_fd_sc_mcu7t5v0__inv_1
Xs_7_87 coarse_s7_86 coarse_s7_87 VDD VDD VSS VSS gf180mcu_fd_sc_mcu7t5v0__inv_1
Xs_7_88 coarse_s7_87 coarse_s7_88 VDD VDD VSS VSS gf180mcu_fd_sc_mcu7t5v0__inv_1
Xs_7_89 coarse_s7_88 coarse_tap_s7 VDD VDD VSS VSS gf180mcu_fd_sc_mcu7t5v0__inv_1

Xdff_0 STOP_IN RN coarse_tap_s0 coarse_q0 VDD VDD VSS VSS gf180mcu_fd_sc_mcu7t5v0__dffrnq_1
Xdff_1 STOP_IN RN coarse_tap_s1 coarse_q1 VDD VDD VSS VSS gf180mcu_fd_sc_mcu7t5v0__dffrnq_1
Xdff_2 STOP_IN RN coarse_tap_s2 coarse_q2 VDD VDD VSS VSS gf180mcu_fd_sc_mcu7t5v0__dffrnq_1
Xdff_3 STOP_IN RN coarse_tap_s3 coarse_q3 VDD VDD VSS VSS gf180mcu_fd_sc_mcu7t5v0__dffrnq_1
Xdff_4 STOP_IN RN coarse_tap_s4 coarse_q4 VDD VDD VSS VSS gf180mcu_fd_sc_mcu7t5v0__dffrnq_1
Xdff_5 STOP_IN RN coarse_tap_s5 coarse_q5 VDD VDD VSS VSS gf180mcu_fd_sc_mcu7t5v0__dffrnq_1
Xdff_6 STOP_IN RN coarse_tap_s6 coarse_q6 VDD VDD VSS VSS gf180mcu_fd_sc_mcu7t5v0__dffrnq_1
Xdff_7 STOP_IN RN coarse_tap_s7 coarse_q7 VDD VDD VSS VSS gf180mcu_fd_sc_mcu7t5v0__dffrnq_1

.ic v(START_IN)=0 v(STOP_IN)=0 v(RN)=0
.options reltol=1e-3 abstol=1e-12 vntol=1e-4 chgtol=1e-16 method=gear temp=25
.control
tran 0.1ns 60ns uic
meas tran coarse_q0_val FIND v(coarse_q0) AT=55n
meas tran coarse_q1_val FIND v(coarse_q1) AT=55n
meas tran coarse_q2_val FIND v(coarse_q2) AT=55n
meas tran coarse_q3_val FIND v(coarse_q3) AT=55n
meas tran coarse_q4_val FIND v(coarse_q4) AT=55n
meas tran coarse_q5_val FIND v(coarse_q5) AT=55n
meas tran coarse_q6_val FIND v(coarse_q6) AT=55n
meas tran coarse_q7_val FIND v(coarse_q7) AT=55n
echo "RESULT coarse_q0=$&coarse_q0_val coarse_q1=$&coarse_q1_val coarse_q2=$&coarse_q2_val coarse_q3=$&coarse_q3_val coarse_q4=$&coarse_q4_val coarse_q5=$&coarse_q5_val coarse_q6=$&coarse_q6_val coarse_q7=$&coarse_q7_val"
.endc
.end
