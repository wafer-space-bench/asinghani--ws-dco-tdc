* Top-level content from sm141064.ngspice
* Copyright 2022 GlobalFoundries PDK Authors
*
* Licensed under the Apache License, Version 2.0 (the "License");
* you may not use this file except in compliance with the License.
* You may obtain a copy of the License at
*
*     https://www.apache.org/licenses/LICENSE-2.0
*
* Unless required by applicable law or agreed to in writing, software
* distributed under the License is distributed on an "AS IS" BASIS,
* WITHOUT WARRANTIES OR CONDITIONS OF ANY KIND, either express or implied.
* See the License for the specific language governing permissions and
* limitations under the License.

*******************************************************************************
* Document No.      : YI-141-SM064
* Revision          : 9
* Process Name      : 0.18um 3.3V/6V high voltage MCU process
* Process ID        : TH18300G0A-PID007347
*					  TH18300G1A-PID007352
*					  TH183G0G6A-PID009507
*					  TH18300G7A-PID009628
*					  TH18300G4A-PID009792
*					  TH18300G9A-PID010186
* Wafer ID          : GT3512K wf#02 (3.3V NMOS, 6.0V NMOS, 6.0V native NMOS and NMOSCAP)
*                     GT3512K wf#06 (3.3V PMOS, 6.0V PMOS, PMOSCAP and BJT)
*                     GT9755L wf#18 (PWELL/DNWELL and DNWELL/Psub diode, Vertical NPN)
*                     JT1042L01 (6V NMOS L=0.6um)
*                     TCXN39W20 W#4 schottky diode
************************************************************************************************
* Models included in this release :
*
*      ModelName          Description
*      ---------          -----------
*      nfet_03v3           Subcircuit model for 3.3V NMOS
*      pfet_03v3           Subcircuit model for 3.3V PMOS
*      nfet_06v0           Subcircuit model for 6.0V NMOS
*      pfet_06v0           Subcircuit model for 6.0V PMOS
*      nfet_03v3_dss       Subcircuit model for 3.3V NMOS with Drain side SAB
*      pfet_03v3_dss       Subcircuit model for 3.3V PMOS with Drain side SAB
*      nfet_06v0_dss       Subcircuit model for 6.0V NMOS with Drain side SAB
*      pfet_06v0_dss       Subcircuit model for 6.0V PMOS with Drain side SAB
*      nfet_06v0_nvt       Subcircuit model for 6.0V native NMOS
*
*      diode_nd2ps_03v3    Model for 3.3V N+/Psub diode
*      diode_pd2nw_03v3    Model for 3.3V P+/Nwell diode
*      diode_nd2ps_06v0    Model for 6.0V N+/Psub diode
*      diode_pd2nw_06v0    Model for 6.0V P+/Nwell diode
*      diode_nw2ps_03v3    Model for 3.3V Nwell/Psub diode
*      diode_nw2ps_06v0    Model for 6.0V Nwell/Psub diode
*      diode_pw2dw         Model for PWELL/DNWELL diode
*      diode_dw2ps         Model for DNWELL/Psub diode
*      sc_diode            Model for Schottky Diode
*
*      pnp_10p00x00p42     Subcircuit GP model for VPNP with emitter size of 10umx0.42um
*      pnp_05p00x00p42     Subcircuit GP model for VPNP with emitter size of 5umx0.42um
*      pnp_10p00x10p00     Subcircuit GP model for VPNP with emitter size of 10umx10um
*      pnp_05p00x05p00     Subcircuit GP model for VPNP with emitter size of 5umx5um
*      npn_10p00x10p00     Subcircuit GP model for VNPN with emitter size of 10umx10um(four terminal)
*      npn_05p00x05p00     Subcircuit GP model for VNPN with emitter size of 5umx5um(four terminal)
*      npn_00p54x16p00     Subcircuit GP model for VNPN with emitter size of 0.54umx16um(four terminal)
*      npn_00p54x08p00     Subcircuit GP model for VNPN with emitter size of 0.54umx8um(four terminal)
*      npn_00p54x04p00     Subcircuit GP model for VNPN with emitter size of 0.54umx4um(four terminal)
*      npn_00p54x02p00     Subcircuit GP model for VNPN with emitter size of 0.54umx2um(four terminal)
*
*      nplus_u             Subcircuit Model for 3-terminal unsalicided n+ diffusion resistor
*      pplus_u             Subcircuit Model for 3-terminal unsalicided P+ diffusion resistor
*      nplus_s             Subcircuit Model for 3-terminal salicided N+ diffusion resistor
*      pplus_s             Subcircuit Model for 3-terminal salicided P+ diffusion resistor
*      nwell               Subcircuit Model for 3-terminal nwell resistor under STI
*      npolyf_u            Subcircuit Model for 3-terminal unsalicided n+ poly resistor
*      ppolyf_u            Subcircuit Model for 3-terminal unsalicided p+ poly resistor
*      npolyf_s            Subcircuit Model for 3-terminal salicided n+ poly resistor
*      ppolyf_s            Subcircuit Model for 3-terminal salicided p+ poly resistor
*      ppolyf_u_1k         Subcircuit Model for 3-terminal 1k high-Rs p+ poly resistor on field oxide (3.3V area)
*      ppolyf_u_2k         Subcircuit Model for 3-terminal 2k high-Rs p+ poly resistor on field oxide (3.3V area)
*      ppolyf_u_1k_6p0     Subcircuit Model for 3-terminal 1k high-Rs p+ poly resistor on field oxide (6.0V area)
*      ppolyf_u_2k_6p0     Subcircuit Model for 3-terminal 2k high-Rs p+ poly resistor on field oxide (6.0V area)
*      ppolyf_u_3k         Subcircuit Model for 3-terminal 3k high-Rs p+ poly resistor on field oxide (both 3.3V & 6.0V area)
*      rm1                 Subcircuit Model for 2-terminal metal 1 resistor
*      rm2                 Subcircuit Model for 2-terminal metal 2 resistor
*      rm3                 Subcircuit Model for 2-terminal metal 3 resistor
*      rm4                 Subcircuit Model for 2-terminal metal 4 resistor
*      tm6k                Subcircuit Model for 2-terminal top metal 6k resistor
*      tm9k                Subcircuit Model for 2-terminal top metal 9k resistor
*      tm11k               Subcircuit Model for 2-terminal top metal 11k resistor
*      tm30k               Subcircuit Model for 2-terminal top metal 30k resistor
*
*      cap_mim_1f5fF       Subcircuit Model for 1.5fF/um2 MIM (*)-usable for Volt <=6V across capacitor
*      cap_mim_1f0fF       Subcircuit Model for 1.0fF/um2 MIM (*)-usable for Volt <=20V across capacitor
*      cap_mim_2f0fF       Subcircuit Model for 2fF/um2 MIM      -usable for Volt <=6V across capacitor
*
*      cap_nmos_03v3       Subcircuit Model for 3.3v inversion-mode  NMOS capacitor
*      cap_pmos_03v3	   Subcircuit Model for 3.3v inversion-mode  PMOS capacitor
*      cap_nmos_06v0       Subcircuit Model for 6.0V inversion-mode  NMOS capacitor
*      cap_pmos_06v0	   Subcircuit Model for 6.0V inversion-mode  PMOS capacitor
*      cap_nmos_03v3_b     Subcircuit Model for 3.3v NMOS in Nwell capacitor
*      cap_pmos_03v3_b	   Subcircuit Model for 3.3v PMOS in Pwell capacitor
*      cap_nmos_06v0_b     Subcircuit Model for 6.0V NMOS in Nwell capacitor
*      cap_pmos_06v0_b	   Subcircuit Model for 6.0V PMOS in Pwell capacitor
*
*      efuse    	       Subcircuit model for 6V/(5V) efuse
************************************************************************************************

* --- typical corner section (resolved) ---
.subckt nfet_03v3_dss d g s b w=10u l=0.28u nf=1 m=1 par=1 s_sab=0.48u d_sab=1.78u as=0 ad=0 ps=0 pd=0 nrd=0 nrs=0 dtemp=0 sa=0 sb=0 sd=0
.param par_vth=0.007148
.param par_k=0.007008
.param par_l=1.5e-7
.param par_w=-1e-7
.param par_leff='l-par_l'
.param par_weff='par*(w-par_w)'
.param p_sqrtarea='sqrt((par_leff)*(par_weff))'
.param var_k='0.7071*par_k*1e-06/p_sqrtarea'
.param mis_k='agauss(0,var_k,1)'
.param var_vth='0.7071*par_vth*1e-06/p_sqrtarea'
.param mis_vth='agauss(0,var_vth,1)'
xr1 d d1 b nplus_u_m1 wr='w' lr='(d_sab==0)?1e-15:d_sab'
xr2 s s1 b nplus_u_m1 wr='w' lr='(s_sab==0)?1e-15:s_sab'
m0 d1 g s1 b nfet_03v3 ad=ad as=as delvto='mis_vth*sw_stat_mismatch' l='l' m=m mulu0='1-mis_k*sw_stat_mismatch' nf=nf nrd=nrd nrs=nrs pd=pd ps=ps sa=sa sb=sb sd=sd w='w'
.ends
.model nfet_03v3.0 nmos
+ a0=0.11197377
+ a1=0
+ a2=1
+ acde=0.6
+ acnqsmod=0
+ agidl=1.3268e-010
+ ags=0.32403844
+ alpha0=2.652013e-006
+ alpha1=0
+ at=23000
+ b0=0
+ b1=0
+ beta0=19.905584
+ bgidl=1.8961e+009
+ binunit=2
+ capmod=2
+ cdsc=0
+ cdscb=0
+ cdscd=0
+ cf=0
+ cgbo=1e-013
+ cgdl=1e-010
+ cgdo=1e-010
+ cgidl=0.5
+ cgsl=1e-010
+ cgso=1e-010
+ cit=0
+ cjs=0.00096797
+ cjswgs=5.9903e-010
+ cjsws=1.5663e-010
+ ckappad=0.6
+ ckappas=0.6
+ clc=1e-007
+ cle=0.6
+ delta=0.0036363636
+ diomod=1
+ dlc=0
+ dlcig=1.5e-007
+ dmcg=1.5e-007
+ drout=0.56
+ dsub=0.5
+ dvt0=0
+ dvt0w=0
+ dvt1=0.53
+ dvt1w=0
+ dvt2=0
+ dvt2w=0
+ dvtp0=0
+ dvtp1=0
+ dwb=0
+ dwc=0
+ dwg=0
+ ef=0.95
+ egidl=0.8
+ em=4.1e+007
+ epsrox=3.9
+ eta0=0.75
+ etab=-0.32
+ eu=1.67
+ fnoimod=1
+ fprout=0
+ geomod=0
+ igbmod=0
+ igcmod=0
+ ijthsfwd=0.1
+ ijthsrev=0.1
+ jss=2.2959e-007
+ jswgs=0
+ jsws=2.1207e-013
+ k1=0.95938091
+ k2=0.054714558
+ k3=0
+ k3b=0
+ keta=-0.14896036
+ kt1=-0.45934558
+ kt1l=0
+ kt2=-0.024730519
+ ku0=0
+ kvsat=0
+ kvth0=0
+ la0=-3.1454545e-009
+ lags=-1.5116364e-008
+ lalpha0=-3.0506364e-013
+ lbeta0=1.2863636e-007
+ ldelta=3.1818182e-009
+ level=54
+ lint=0
+ lk1=-9.9985454e-008
+ lk2=-4.1647636e-008
+ lketa=3.8830182e-008
+ lkt1=4.2126364e-008
+ lkt2=1.2545455e-009
+ ll=0
+ lln=1
+ lmax=5e-007
+ lmin=2.8e-007
+ lpclm=-4.729e-008
+ lpe0=1.1e-007
+ lpeb=0
+ ltvoff=0
+ lu0=4.6525455e-009
+ lua=7.0220545e-016
+ lub=-7.9058636e-025
+ lub1=2.8745455e-025
+ luc=-6.1360545e-017
+ luc1=-3.8181818e-018
+ lute=9.0909091e-008
+ lvoff=3.9354545e-009
+ lvsat=-0.0027272727
+ lvth0=-3.8715455e-008
+ lw=0
+ lwl=0
+ lwn=1
+ minv=-0.25
+ mjs=0.32071
+ mjswgs=0.32059
+ mjsws=0.1
+ mobmod=0
+ moin=15
+ ndep=3e+017
+ nfactor=1
+ ngate=6e+019
+ njs=1.01
+ noff=2
+ noia='nfet_03v3_noia'
+ noib='nfet_03v3_noib'
+ noic='nfet_03v3_noic'
+ nsd=1e+020
+ ntnoi=1
+ pa0=1.7450182e-015
+ pags=-1.2213818e-014
+ palpha0=-1.3658182e-020
+ paramchk=1
+ pbeta0=8.7272727e-016
+ pbs=0.70172
+ pbswgs=0.74743
+ pbsws=0.8062
+ pclm=0.3741
+ pdiblc1=0.39
+ pdiblc2=0.003171
+ pdiblcb=0.2
+ pdits=0
+ pditsd=0
+ pditsl=0
+ permod=1
+ phin=0.07
+ pk2=5.388e-015
+ pketa=-2.4261818e-015
+ pkt1=-8.6530909e-015
+ pkt2=-2.9672727e-016
+ ppclm=8.5658182e-015
+ prt=0
+ prwb=0
+ prwg=0
+ pscbe1=6.6469e+008
+ pscbe2=1.638e-005
+ ptvoff=0
+ pu0=-6.5127273e-016
+ pua=-1.4149745e-022
+ pub=9.2644364e-032
+ pub1=-5.7490909e-032
+ puc=5.4467782e-024
+ puc1=1.8327273e-024
+ pute=-4.3636364e-014
+ pvag=0
+ pvoff=-1.4858182e-015
+ pvsat=1.3090909e-009
+ pvth0=4.3636364e-016
+ rbodymod=0
+ rdsmod=0
+ rdsw=530
+ rdswmin=50
+ rdwmin=0
+ rgatemod=0
+ rsh=7
+ rswmin=0
+ saref=4.4e-007
+ sbref=4.4e-007
+ tcj=0.0009438
+ tcjsw=0.00060474
+ tcjswg=0.001
+ tnoimod=0
+ tnom=25
+ toxe=8e-009
+ toxm=8e-009
+ toxp=8e-009
+ toxref=8e-009
+ tpb=0.0018129
+ tpbsw=5e-005
+ tpbswg=0.0016872
+ trnqsmod=0
+ tvoff=0.001
+ u0=0.023671338
+ ua=-1.1554452e-009
+ ua1=1.675e-009
+ ub=3.3771156e-018
+ ub1=-4.1945234e-018
+ uc=2.2660166e-010
+ uc1=-4.2363636e-011
+ ute=-1.5675325
+ vbm=-3
+ version=4.5
+ vfbcv=-1
+ voff=-0.1262652
+ voffcv=0.005
+ voffl=0
+ vsat=92454.546
+ vth0=0.70837662
+ w0=5e-007
+ wa0=-6.2322078e-009
+ wags=4.7930493e-008
+ walpha0=4.8779221e-014
+ wbeta0=1.3848312e-007
+ wint=1e-008
+ wk2=-1.9242857e-008
+ wketa=8.1643636e-009
+ wkt1=3.2086753e-008
+ wkt2=1.0597403e-009
+ wl=0
+ wln=1
+ wmax=5e-007
+ wmin=2.2e-007
+ wpclm=2.1028364e-008
+ wr=1
+ wtvoff=0
+ wu0=4.6066597e-009
+ wua=2.7073777e-016
+ wub=-4.093733e-025
+ wub1=3.3492467e-025
+ wuc=-3.2577351e-017
+ wuc1=-6.5454545e-018
+ wute=1.0441558e-007
+ wvoff=5.3064935e-009
+ wvsat=-0.00021818182
+ wvth0=-1.430587e-008
+ ww=0
+ wwl=0
+ wwn=1
+ xj=1e-007
+ xl=0
+ xpart=0
+ xtis=3
+ xw=0
.model nfet_03v3.1 nmos
+ a0=1.0861147
+ a1=0
+ a2=1
+ acde=0.6
+ acnqsmod=0
+ agidl=1.3268e-010
+ ags=0.47870122
+ alpha0=6.5720816e-006
+ alpha1=0
+ at=23000
+ b0=0
+ b1=0
+ beta0=22.625306
+ bgidl=1.8961e+009
+ binunit=2
+ capmod=2
+ cdsc=0
+ cdscb=0
+ cdscd=0
+ cf=0
+ cgbo=1e-013
+ cgdl=1e-010
+ cgdo=1e-010
+ cgidl=0.5
+ cgsl=1e-010
+ cgso=1e-010
+ cit=0
+ cjs=0.00096797
+ cjswgs=5.9903e-010
+ cjsws=1.5663e-010
+ ckappad=0.6
+ ckappas=0.6
+ clc=1e-007
+ cle=0.6
+ delta=0.0014285714
+ diomod=1
+ dlc=0
+ dlcig=1.5e-007
+ dmcg=1.5e-007
+ drout=0.56
+ dsub=0.5
+ dvt0=0
+ dvt0w=0
+ dvt1=0.53
+ dvt1w=0
+ dvt2=0
+ dvt2w=0
+ dvtp0=0
+ dvtp1=0
+ dwb=0
+ dwc=0
+ dwg=0
+ ef=0.95
+ egidl=0.8
+ em=4.1e+007
+ epsrox=3.9
+ eta0=0.75
+ etab=-0.32
+ eu=1.67
+ fnoimod=1
+ fprout=0
+ geomod=0
+ igbmod=0
+ igcmod=0
+ ijthsfwd=0.1
+ ijthsrev=0.1
+ jss=2.2959e-007
+ jswgs=0
+ jsws=2.1207e-013
+ k1=0.74639857
+ k2=0.0237458
+ k3=0
+ k3b=0
+ keta=-0.028417143
+ kt1=-0.33916633
+ kt1l=0
+ kt2=-0.020311225
+ ku0=0
+ kvsat=0
+ kvth0=0
+ la0=-4.9021592e-007
+ lags=-9.2447755e-008
+ lalpha0=-2.265098e-012
+ lbeta0=-1.2312245e-006
+ ldelta=4.2857143e-009
+ level=54
+ lint=0
+ lk1=6.5057143e-009
+ lk2=-2.6163257e-008
+ lketa=-2.1441429e-008
+ lkt1=-1.7963265e-008
+ lkt2=-9.5510204e-010
+ ll=0
+ lln=1
+ lmax=1.2e-006
+ lmin=5e-007
+ lpclm=9.8313061e-008
+ lpdiblc2=9.06e-010
+ lpe0=1.1e-007
+ lpeb=0
+ ltvoff=0
+ lu0=1.6503673e-009
+ lua=7.7258204e-016
+ lub=-6.4387347e-025
+ lub1=-4.0760816e-025
+ luc=9.6333061e-018
+ luc1=5.1428571e-018
+ lvoff=-2.8273469e-009
+ lvsat=0.0017142857
+ lvth0=-2.3433061e-008
+ lw=0
+ lwl=0
+ lwn=1
+ minv=-0.25
+ mjs=0.32071
+ mjswgs=0.32059
+ mjsws=0.1
+ mobmod=0
+ moin=15
+ ndep=3e+017
+ nfactor=1
+ ngate=6e+019
+ njs=1.01
+ noff=2
+ noia='nfet_03v3_noia'
+ noib='nfet_03v3_noib'
+ noic='nfet_03v3_noic'
+ nsd=1e+020
+ ntnoi=1
+ pa0=2.4627526e-014
+ pags=-9.9007347e-015
+ palpha0=1.8396735e-020
+ paramchk=1
+ pbeta0=2.4538775e-013
+ pbs=0.70172
+ pbswgs=0.74743
+ pbsws=0.8062
+ pclm=0.082893878
+ pdiblc1=0.39
+ pdiblc2=0.001359
+ pdiblcb=0.2
+ pdits=0
+ pditsd=0
+ pditsl=0
+ permod=1
+ phin=0.07
+ pk2=-2.7269486e-015
+ pketa=5.3691429e-015
+ pkt1=8.6223674e-015
+ pkt2=2.5273469e-016
+ ppclm=-2.8711837e-015
+ prt=0
+ prwb=0
+ prwg=0
+ pscbe1=6.6469e+008
+ pscbe2=1.638e-005
+ ptvoff=0
+ pu0=1.2234122e-015
+ pua=-2.976098e-023
+ pub=-9.8501878e-032
+ pub1=8.1521633e-032
+ puc=-1.1961815e-023
+ puc1=-2.4685714e-024
+ pvag=0
+ pvoff=3.2032653e-016
+ pvsat=2.0571429e-009
+ pvth0=-5.642449e-016
+ rbodymod=0
+ rdsmod=0
+ rdsw=530
+ rdswmin=50
+ rdwmin=0
+ rgatemod=0
+ rsh=7
+ rswmin=0
+ saref=4.4e-007
+ sbref=4.4e-007
+ tcj=0.0009438
+ tcjsw=0.00060474
+ tcjswg=0.001
+ tnoimod=0
+ tnom=25
+ toxe=8e-009
+ toxm=8e-009
+ toxp=8e-009
+ toxref=8e-009
+ tpb=0.0018129
+ tpbsw=5e-005
+ tpbswg=0.0016872
+ trnqsmod=0
+ tvoff=0.001
+ u0=0.029675694
+ ua=-1.2961984e-009
+ ua1=1.675e-009
+ ub=3.0836898e-018
+ ub1=-2.804398e-018
+ uc=8.4613959e-011
+ uc1=-6.0285714e-011
+ ute=-1.3857143
+ vbm=-3
+ version=4.5
+ vfbcv=-1
+ voff=-0.11273959
+ voffcv=0.005
+ voffl=0
+ vsat=83571.429
+ vth0=0.67781184
+ w0=5e-007
+ wa0=-5.1997224e-008
+ wags=4.3304327e-008
+ walpha0=-1.5330612e-014
+ wbeta0=-3.5054694e-007
+ wint=1e-008
+ wk2=-3.01296e-009
+ wketa=-7.4262857e-009
+ wkt1=-2.4641633e-009
+ wkt2=-3.9183673e-011
+ wl=0
+ wln=1
+ wmax=5e-007
+ wmin=2.2e-007
+ wpclm=4.3902367e-008
+ wr=1
+ wtvoff=0
+ wu0=8.572898e-010
+ wua=4.7264816e-017
+ wub=-2.7080816e-026
+ wub1=5.6899592e-026
+ wuc=2.2398367e-018
+ wuc1=2.0571429e-018
+ wute=1.7142857e-008
+ wvoff=1.6942041e-009
+ wvsat=-0.0017142857
+ wvth0=-1.2304653e-008
+ ww=0
+ wwl=0
+ wwn=1
+ xj=1e-007
+ xl=0
+ xpart=0
+ xtis=3
+ xw=0
.model nfet_03v3.2 nmos
+ a0=1.224418
+ a1=0
+ a2=1
+ acde=0.6
+ acnqsmod=0
+ agidl=1.3268e-010
+ ags=0.25784649
+ alpha0=7.5243347e-005
+ alpha1=0
+ at=23000
+ b0=0
+ b1=0
+ beta0=24.210162
+ bgidl=1.8961e+009
+ binunit=2
+ capmod=2
+ cdsc=0
+ cdscb=0
+ cdscd=0
+ cf=0
+ cgbo=1e-013
+ cgdl=1e-010
+ cgdo=1e-010
+ cgidl=0.5
+ cgsl=1e-010
+ cgso=1e-010
+ cit=0
+ cjs=0.00096797
+ cjswgs=5.9903e-010
+ cjsws=1.5663e-010
+ ckappad=0.6
+ ckappas=0.6
+ clc=1e-007
+ cle=0.6
+ delta=0.0027272727
+ diomod=1
+ dlc=0
+ dlcig=1.5e-007
+ dmcg=1.5e-007
+ drout=0.56
+ dsub=0.5
+ dvt0=0
+ dvt0w=0
+ dvt1=0.53
+ dvt1w=0
+ dvt2=0
+ dvt2w=0
+ dvtp0=0
+ dvtp1=0
+ dwb=0
+ dwc=0
+ dwg=0
+ ef=0.95
+ egidl=0.8
+ em=4.1e+007
+ epsrox=3.9
+ eta0=0.75
+ etab=-0.32
+ eu=1.67
+ fnoimod=1
+ fprout=0
+ geomod=0
+ igbmod=0
+ igcmod=0
+ ijthsfwd=0.1
+ ijthsrev=0.1
+ jss=2.2959e-007
+ jswgs=0
+ jsws=2.1207e-013
+ k1=0.79593364
+ k2=0.0056393844
+ k3=0
+ k3b=0
+ keta=-0.019651071
+ kt1=-0.32898149
+ kt1l=0
+ kt2=-0.021107143
+ ku0=0
+ kvsat=0
+ kvth0=0
+ la0=-6.5617987e-007
+ lags=1.7257792e-007
+ lalpha0=-8.4670617e-011
+ lbeta0=-3.133052e-006
+ ldelta=2.7272727e-009
+ level=54
+ lint=0
+ lk1=-5.2936364e-008
+ lk2=-4.4355584e-009
+ lketa=-3.1960714e-008
+ lkt1=-3.0185065e-008
+ ll=0
+ lln=1
+ lmax=1e-005
+ lmin=1.2e-006
+ lpclm=-2.9236364e-008
+ lpdiblc2=1.7686364e-009
+ lpe0=1.1e-007
+ lpeb=0
+ ltvoff=0
+ lu0=-1.6755195e-009
+ lua=1.9570909e-016
+ lub=-2.347987e-025
+ lub1=-7.5296104e-025
+ luc=-6.9921429e-018
+ lvoff=1.3461039e-008
+ lvth0=-3.224026e-009
+ lw=0
+ lwl=0
+ lwn=1
+ minv=-0.25
+ mjs=0.32071
+ mjswgs=0.32059
+ mjsws=0.1
+ mobmod=0
+ moin=15
+ ndep=3e+017
+ nfactor=1
+ ngate=6e+019
+ njs=1.01
+ noff=2
+ noia='nfet_03v3_noia'
+ noib='nfet_03v3_noib'
+ noic='nfet_03v3_noic'
+ nsd=1e+020
+ ntnoi=1
+ pa0=-4.2919481e-014
+ pags=4.5191688e-014
+ palpha0=-9.043013e-018
+ paramchk=1
+ pbeta0=-3.1184416e-013
+ pbs=0.70172
+ pbswgs=0.74743
+ pbsws=0.8062
+ pclm=0.18918506
+ pdiblc1=0.39
+ pdiblc2=0.00064013636
+ pdiblcb=0.2
+ pdits=0
+ pditsd=0
+ pditsl=0
+ permod=1
+ phin=0.07
+ pk2=2.6091117e-015
+ pketa=-2.7504935e-015
+ pkt1=1.4488831e-014
+ ppclm=4.7225454e-014
+ prt=0
+ prwb=0
+ prwg=0
+ pscbe1=6.6469e+008
+ pscbe2=1.638e-005
+ ptvoff=0
+ pu0=1.447013e-015
+ pua=1.9701818e-023
+ pub=-1.1174026e-031
+ pub1=1.231013e-031
+ puc=1.4030649e-024
+ pvag=0
+ pvoff=-1.4493507e-016
+ pvth0=-3.6888312e-015
+ rbodymod=0
+ rdsmod=0
+ rdsw=530
+ rdswmin=50
+ rdwmin=0
+ rgatemod=0
+ rsh=7
+ rswmin=0
+ saref=4.4e-007
+ sbref=4.4e-007
+ tcj=0.0009438
+ tcjsw=0.00060474
+ tcjswg=0.001
+ tnoimod=0
+ tnom=25
+ toxe=8e-009
+ toxm=8e-009
+ toxp=8e-009
+ toxref=8e-009
+ tpb=0.0018129
+ tpbsw=5e-005
+ tpbswg=0.0016872
+ trnqsmod=0
+ tvoff=0.001
+ u0=0.032447266
+ ua=-8.1547091e-010
+ ua1=1.675e-009
+ ub=2.7427942e-018
+ ub1=-2.5166039e-018
+ uc=9.84685e-011
+ uc1=-5.6e-011
+ ute=-1.3857143
+ vbm=-3
+ version=4.5
+ vfbcv=-1
+ voff=-0.12631325
+ voffcv=0.005
+ voffl=0
+ vsat=85000
+ vth0=0.66097097
+ w0=5e-007
+ wa0=4.291948e-009
+ wags=-2.606026e-009
+ walpha0=7.5358442e-012
+ wbeta0=1.1381299e-007
+ wint=1e-008
+ wk2=-7.4596769e-009
+ wketa=-6.5992208e-010
+ wkt1=-7.3528831e-009
+ wkt2=1.7142857e-010
+ wl=0
+ wln=1
+ wmax=5e-007
+ wmin=2.2e-007
+ wpclm=2.1551688e-009
+ wr=1
+ wtvoff=0
+ wu0=6.7095584e-010
+ wua=6.0458182e-018
+ wub=-1.6048831e-026
+ wub1=2.224987e-026
+ wuc=-8.8975636e-018
+ wute=1.7142857e-008
+ wvoff=2.0819221e-009
+ wvth0=-9.7008312e-009
+ ww=0
+ wwl=0
+ wwn=1
+ xj=1e-007
+ xl=0
+ xpart=0
+ xtis=3
+ xw=0
.model nfet_03v3.3 nmos
+ a0=1.1588
+ a1=0
+ a2=1
+ acde=0.6
+ acnqsmod=0
+ agidl=1.3268e-010
+ ags=0.27510429
+ alpha0=6.6776286e-005
+ alpha1=0
+ at=23000
+ b0=0
+ b1=0
+ beta0=23.896857
+ bgidl=1.8961e+009
+ binunit=2
+ capmod=2
+ cdsc=0
+ cdscb=0
+ cdscd=0
+ cf=0
+ cgbo=1e-013
+ cgdl=1e-010
+ cgdo=1e-010
+ cgidl=0.5
+ cgsl=1e-010
+ cgso=1e-010
+ cit=0
+ cjs=0.00096797
+ cjswgs=5.9903e-010
+ cjsws=1.5663e-010
+ ckappad=0.6
+ ckappas=0.6
+ clc=1e-007
+ cle=0.6
+ delta=0.003
+ diomod=1
+ dlc=0
+ dlcig=1.5e-007
+ dmcg=1.5e-007
+ drout=0.56
+ dsub=0.5
+ dvt0=0
+ dvt0w=0
+ dvt1=0.53
+ dvt1w=0
+ dvt2=0
+ dvt2w=0
+ dvtp0=0
+ dvtp1=0
+ dwb=0
+ dwc=0
+ dwg=0
+ ef=0.95
+ egidl=0.8
+ em=4.1e+007
+ epsrox=3.9
+ eta0=0.75
+ etab=-0.32
+ eu=1.67
+ fnoimod=1
+ fprout=0
+ geomod=0
+ igbmod=0
+ igcmod=0
+ ijthsfwd=0.1
+ ijthsrev=0.1
+ jss=2.2959e-007
+ jswgs=0
+ jsws=2.1207e-013
+ k1=0.79064
+ k2=0.0051958286
+ k3=0
+ k3b=0
+ keta=-0.022847143
+ kt1=-0.332
+ kt1l=0
+ kt2=-0.021107143
+ ku0=0
+ kvsat=0
+ kvth0=0
+ level=54
+ lint=0
+ ll=0
+ lln=1
+ lmax=5.0001e-005
+ lmin=1e-005
+ lpe0=1.1e-007
+ lpeb=0
+ ltvoff=0
+ lw=0
+ lwl=0
+ lwn=1
+ minv=-0.25
+ mjs=0.32071
+ mjswgs=0.32059
+ mjsws=0.1
+ mobmod=0
+ moin=15
+ ndep=3e+017
+ nfactor=1
+ ngate=6e+019
+ njs=1.01
+ noff=2
+ noia='nfet_03v3_noia'
+ noib='nfet_03v3_noib'
+ noic='nfet_03v3_noic'
+ nsd=1e+020
+ ntnoi=1
+ paramchk=1
+ pbs=0.70172
+ pbswgs=0.74743
+ pbsws=0.8062
+ pclm=0.18626143
+ pdiblc1=0.39
+ pdiblc2=0.000817
+ pdiblcb=0.2
+ pdits=0
+ pditsd=0
+ pditsl=0
+ permod=1
+ phin=0.07
+ prt=0
+ prwb=0
+ prwg=0
+ pscbe1=6.6469e+008
+ pscbe2=1.638e-005
+ ptvoff=0
+ pvag=0
+ rbodymod=0
+ rdsmod=0
+ rdsw=530
+ rdswmin=50
+ rdwmin=0
+ rgatemod=0
+ rsh=7
+ rswmin=0
+ saref=4.4e-007
+ sbref=4.4e-007
+ tcj=0.0009438
+ tcjsw=0.00060474
+ tcjswg=0.001
+ tnoimod=0
+ tnom=25
+ toxe=8e-009
+ toxm=8e-009
+ toxp=8e-009
+ toxref=8e-009
+ tpb=0.0018129
+ tpbsw=5e-005
+ tpbswg=0.0016872
+ trnqsmod=0
+ tvoff=0.001
+ u0=0.032279714
+ ua=-7.959e-010
+ ua1=1.675e-009
+ ub=2.7193143e-018
+ ub1=-2.5919e-018
+ uc=9.7769286e-011
+ uc1=-5.6e-011
+ ute=-1.3857143
+ vbm=-3
+ version=4.5
+ vfbcv=-1
+ voff=-0.12496714
+ voffcv=0.005
+ voffl=0
+ vsat=85000
+ vth0=0.66064857
+ w0=5e-007
+ wags=1.9131429e-009
+ walpha0=6.6315429e-012
+ wbeta0=8.2628571e-008
+ wint=1e-008
+ wk2=-7.1987657e-009
+ wketa=-9.3497143e-010
+ wkt1=-5.904e-009
+ wkt2=1.7142857e-010
+ wl=0
+ wln=1
+ wmax=5e-007
+ wmin=2.2e-007
+ wpclm=6.8777143e-009
+ wr=1
+ wtvoff=0
+ wu0=8.1565714e-010
+ wua=8.016e-018
+ wub=-2.7222857e-026
+ wub1=3.456e-026
+ wuc=-8.7572571e-018
+ wute=1.7142857e-008
+ wvoff=2.0674286e-009
+ wvth0=-1.0069714e-008
+ ww=0
+ wwl=0
+ wwn=1
+ xj=1e-007
+ xl=0
+ xpart=0
+ xtis=3
+ xw=0
.model nfet_03v3.4 nmos
+ a0=0.10680558
+ a1=0
+ a2=1
+ acde=0.6
+ acnqsmod=0
+ agidl=1.3268e-010
+ ags=0.35500309
+ alpha0=2.6500109e-006
+ alpha1=0
+ at=23000
+ b0=0
+ b1=0
+ beta0=20.982852
+ bgidl=1.8961e+009
+ binunit=2
+ capmod=2
+ cdsc=0
+ cdscb=0
+ cdscd=0
+ cf=0
+ cgbo=1e-013
+ cgdl=1e-010
+ cgdo=1e-010
+ cgidl=0.5
+ cgsl=1e-010
+ cgso=1e-010
+ cit=0
+ cjs=0.00096797
+ cjswgs=5.9903e-010
+ cjsws=1.5663e-010
+ ckappad=0.6
+ ckappas=0.6
+ clc=1e-007
+ cle=0.6
+ delta=0.0036363636
+ diomod=1
+ dlc=0
+ dlcig=1.5e-007
+ dmcg=1.5e-007
+ drout=0.56
+ dsub=0.5
+ dvt0=0
+ dvt0w=0
+ dvt1=0.53
+ dvt1w=0
+ dvt2=0
+ dvt2w=0
+ dvtp0=0
+ dvtp1=0
+ dwb=0
+ dwc=0
+ dwg=0
+ ef=0.95
+ egidl=0.8
+ em=4.1e+007
+ epsrox=3.9
+ eta0=0.75
+ etab=-0.32
+ eu=1.67
+ fnoimod=1
+ fprout=0
+ geomod=0
+ igbmod=0
+ igcmod=0
+ ijthsfwd=0.1
+ ijthsrev=0.1
+ jss=2.2959e-007
+ jswgs=0
+ jsws=2.1207e-013
+ k1=0.95938091
+ k2=0.041255727
+ k3=0
+ k3b=0
+ keta=-0.12490989
+ kt1=-0.37773746
+ kt1l=0
+ kt2=-0.014603854
+ ku0=0
+ kvsat=0
+ kvth0=0
+ la0=-1.6983636e-009
+ lags=-1.1780546e-008
+ lalpha0=-2.8170545e-013
+ lbeta0=-8.9454546e-008
+ ldelta=3.1818182e-009
+ level=54
+ lint=0
+ lk1=-9.9985454e-008
+ lk2=-3.7879164e-008
+ lketa=3.0254945e-008
+ lkt1=1.6718727e-008
+ lkt2=-3.3230727e-009
+ ll=0
+ lln=1
+ lmax=5e-007
+ lmin=2.8e-007
+ lpclm=-8.0088e-008
+ lpe0=1.1e-007
+ lpeb=0
+ ltvoff=0
+ lu0=4.0251818e-009
+ lua=3.9938436e-016
+ lub=-9.0230909e-026
+ lub1=2.4878e-025
+ luc=-3.4349127e-017
+ lvoff=-9.2114546e-009
+ lvsat=0.0042909091
+ lvth0=-4.1979273e-008
+ lw=0
+ lwl=0
+ lwn=1
+ minv=-0.25
+ mjs=0.32071
+ mjswgs=0.32059
+ mjsws=0.1
+ mobmod=0
+ moin=15
+ ndep=3e+017
+ nfactor=1
+ ngate=6e+019
+ njs=1.01
+ noff=2
+ noia='nfet_03v3_noia'
+ noib='nfet_03v3_noib'
+ noic='nfet_03v3_noic'
+ nsd=1e+020
+ ntnoi=1
+ pa0=1.0504145e-015
+ pags=-1.3815011e-014
+ palpha0=-2.4870109e-020
+ paramchk=1
+ pbeta0=1.0555636e-013
+ pbs=0.70172
+ pbswgs=0.74743
+ pbsws=0.8062
+ pclm=0.45921829
+ pdiblc1=0.39
+ pdiblc2=0.003171
+ pdiblcb=0.2
+ pdits=0
+ pditsd=0
+ pditsl=0
+ permod=1
+ phin=0.07
+ pk2=3.5791331e-015
+ pketa=1.6899316e-015
+ pkt1=3.5425745e-015
+ pkt2=1.9005294e-015
+ ppclm=2.4308858e-014
+ prt=0
+ prwb=0
+ prwg=0
+ pscbe1=6.6469e+008
+ pscbe2=1.638e-005
+ ptvoff=0
+ pu0=-3.5013818e-016
+ pua=3.8566691e-024
+ pub=-2.4352626e-031
+ pub1=-3.8927127e-032
+ puc=-7.5187026e-024
+ pvag=0
+ pvoff=4.8246982e-015
+ pvsat=-2.0596364e-009
+ pvth0=2.0029964e-015
+ rbodymod=0
+ rdsmod=0
+ rdsw=530
+ rdswmin=50
+ rdwmin=0
+ rgatemod=0
+ rsh=7
+ rswmin=0
+ saref=4.4e-007
+ sbref=4.4e-007
+ tcj=0.0009438
+ tcjsw=0.00060474
+ tcjswg=0.001
+ tnoimod=0
+ tnom=25
+ toxe=8e-009
+ toxm=8e-009
+ toxp=8e-009
+ toxref=8e-009
+ tpb=0.0018129
+ tpbsw=5e-005
+ tpbswg=0.0016872
+ trnqsmod=0
+ tvoff=0.001
+ u0=0.033011551
+ ua=-6.3005701e-010
+ ua1=1.675e-009
+ ub=2.2836418e-018
+ ub1=-3.65896e-018
+ uc=1.5877203e-010
+ uc1=-5.6e-011
+ ute=-1.4342857
+ vbm=-3
+ version=4.5
+ vfbcv=-1
+ voff=-0.079311948
+ voffcv=0.005
+ voffl=0
+ vsat=71618.182
+ vth0=0.72356597
+ w0=5e-007
+ wa0=-3.7514805e-009
+ wags=3.3067462e-008
+ walpha0=4.9740218e-014
+ wbeta0=-3.786053e-007
+ wint=1e-008
+ wk2=-1.2782618e-008
+ wketa=-3.3798633e-009
+ wkt1=-7.0851491e-009
+ wkt2=-3.8010589e-009
+ wl=0
+ wln=1
+ wmax=1.2e-006
+ wmin=5e-007
+ wpclm=-1.9828414e-008
+ wr=1
+ wtvoff=0
+ wu0=1.2335751e-010
+ wua=1.8551439e-017
+ wub=1.1549411e-025
+ wub1=7.7854254e-026
+ wuc=-1.9125195e-020
+ wute=4.0457143e-008
+ wvoff=-1.7231065e-008
+ wvsat=0.0097832727
+ wvth0=-2.1596758e-008
+ ww=0
+ wwl=0
+ wwn=1
+ xj=1e-007
+ xl=0
+ xpart=0
+ xtis=3
+ xw=0
.model nfet_03v3.5 nmos
+ a0=0.97533082
+ a1=0
+ a2=1
+ acde=0.6
+ acnqsmod=0
+ agidl=1.3268e-010
+ ags=0.441074
+ alpha0=6.8164074e-006
+ alpha1=0
+ at=23000
+ b0=0
+ b1=0
+ beta0=21.036008
+ bgidl=1.8961e+009
+ binunit=2
+ capmod=2
+ cdsc=0
+ cdscb=0
+ cdscd=0
+ cf=0
+ cgbo=1e-013
+ cgdl=1e-010
+ cgdo=1e-010
+ cgidl=0.5
+ cgsl=1e-010
+ cgso=1e-010
+ cit=0
+ cjs=0.00096797
+ cjswgs=5.9903e-010
+ cjsws=1.5663e-010
+ ckappad=0.6
+ ckappas=0.6
+ clc=1e-007
+ cle=0.6
+ delta=0.0014285714
+ diomod=1
+ dlc=0
+ dlcig=1.5e-007
+ dmcg=1.5e-007
+ drout=0.56
+ dsub=0.5
+ dvt0=0
+ dvt0w=0
+ dvt1=0.53
+ dvt1w=0
+ dvt2=0
+ dvt2w=0
+ dvtp0=0
+ dvtp1=0
+ dwb=0
+ dwc=0
+ dwg=0
+ ef=0.95
+ egidl=0.8
+ em=4.1e+007
+ epsrox=3.9
+ eta0=0.75
+ etab=-0.32
+ eu=1.67
+ fnoimod=1
+ fprout=0
+ geomod=0
+ igbmod=0
+ igcmod=0
+ ijthsfwd=0.1
+ ijthsrev=0.1
+ jss=2.2959e-007
+ jswgs=0
+ jsws=2.1207e-013
+ k1=0.76833212
+ k2=0.0082103273
+ k3=0
+ k3b=0
+ keta=-0.043888571
+ kt1=-0.4079911
+ kt1l=0
+ kt2=-0.031229592
+ ku0=0
+ kvsat=0
+ kvth0=0
+ la0=-4.3596098e-007
+ lags=-5.4816e-008
+ lalpha0=-2.3649037e-012
+ lbeta0=-1.1603265e-007
+ ldelta=4.2857143e-009
+ level=54
+ lint=0
+ lk1=-4.4610612e-009
+ lk2=-2.1356464e-008
+ lketa=-1.0255714e-008
+ lkt1=3.1845551e-008
+ lkt2=4.9897959e-009
+ ll=0
+ lln=1
+ lmax=1.2e-006
+ lmin=5e-007
+ lpclm=4.0921959e-008
+ lpdiblc2=9.06e-010
+ lpe0=1.1e-007
+ lpeb=0
+ ltvoff=0
+ lu0=4.9403755e-009
+ lua=6.6367861e-016
+ lub=-3.6042122e-025
+ lub1=-1.7578531e-025
+ luc=4.0383673e-018
+ luc1=3.1443869e-017
+ lvoff=1.1378694e-008
+ lvsat=-0.0041142857
+ lvth0=-1.7716408e-008
+ lw=0
+ lwl=0
+ lwn=1
+ minv=-0.25
+ mjs=0.32071
+ mjswgs=0.32059
+ mjsws=0.1
+ mobmod=0
+ moin=15
+ ndep=3e+017
+ nfactor=1
+ ngate=6e+019
+ njs=1.01
+ noff=2
+ noia='nfet_03v3_noia'
+ noib='nfet_03v3_noib'
+ noic='nfet_03v3_noic'
+ nsd=1e+020
+ ntnoi=1
+ pa0=-1.4148441e-015
+ pags=-2.7963977e-014
+ palpha0=6.6303478e-020
+ paramchk=1
+ pbeta0=-2.8990433e-013
+ pbs=0.70172
+ pbswgs=0.74743
+ pbsws=0.8062
+ pclm=0.21719837
+ pdiblc1=0.39
+ pdiblc2=0.001359
+ pdiblcb=0.2
+ pdits=0
+ pditsd=0
+ pditsl=0
+ permod=1
+ phin=0.07
+ pk1=5.2640522e-015
+ pk2=-5.0342094e-015
+ pkt1=-1.5285865e-014
+ pkt2=-2.6008163e-015
+ ppclm=2.4676545e-014
+ prt=0
+ prwb=0
+ prwg=0
+ pscbe1=6.6469e+008
+ pscbe2=1.638e-005
+ ptvoff=0
+ pu0=-3.5579167e-016
+ pua=2.2512666e-023
+ pub=-2.3455895e-031
+ pub1=-2.9753339e-032
+ puc=-9.2762449e-024
+ puc1=-1.5093057e-023
+ pvag=0
+ pvoff=-6.4985731e-015
+ pvsat=4.8548571e-009
+ pvth0=-3.3082384e-015
+ rbodymod=0
+ rdsmod=0
+ rdsw=530
+ rdswmin=50
+ rdwmin=0
+ rgatemod=0
+ rsh=7
+ rswmin=0
+ saref=4.4e-007
+ sbref=4.4e-007
+ tcj=0.0009438
+ tcjsw=0.00060474
+ tcjswg=0.001
+ tnoimod=0
+ tnom=25
+ toxe=8e-009
+ toxm=8e-009
+ toxp=8e-009
+ toxref=8e-009
+ tpb=0.0018129
+ tpbsw=5e-005
+ tpbswg=0.0016872
+ trnqsmod=0
+ tvoff=0.001
+ u0=0.031181163
+ ua=-1.1586455e-009
+ ua1=1.675e-009
+ ub=2.8240225e-018
+ ub1=-2.8098294e-018
+ uc=8.1997037e-011
+ uc1=-1.1888774e-010
+ ute=-1.4342857
+ vbm=-3
+ version=4.5
+ vfbcv=-1
+ voff=-0.12049225
+ voffcv=0.005
+ voffl=0
+ vsat=88428.571
+ vth0=0.67504024
+ w0=5e-007
+ wa0=1.1790367e-009
+ wags=6.1365394e-008
+ walpha0=-1.3260696e-013
+ wbeta0=4.1231608e-007
+ wint=1e-008
+ wk1=-1.0528104e-008
+ wk2=4.4440669e-009
+ wkt1=3.0571729e-008
+ wkt2=5.2016327e-009
+ wl=0
+ wln=1
+ wmax=1.2e-006
+ wmin=5e-007
+ wpclm=-2.0563788e-008
+ wr=1
+ wtvoff=0
+ wu0=1.3466449e-010
+ wua=-1.8760555e-017
+ wub=9.755951e-026
+ wub1=5.9506678e-026
+ wuc=3.4959595e-018
+ wuc1=3.0186115e-017
+ wute=4.0457143e-008
+ wvoff=5.4154776e-009
+ wvsat=-0.0040457143
+ wvth0=-1.0974289e-008
+ ww=0
+ wwl=0
+ wwn=1
+ xj=1e-007
+ xl=0
+ xpart=0
+ xtis=3
+ xw=0
.model nfet_03v3.6 nmos
+ a0=1.2333595
+ a1=0
+ a2=1
+ acde=0.6
+ acnqsmod=0
+ agidl=1.3268e-010
+ ags=0.28370796
+ alpha0=9.0921047e-005
+ alpha1=0
+ at=23000
+ b0=0
+ b1=0
+ beta0=24.039866
+ bgidl=1.8961e+009
+ binunit=2
+ capmod=2
+ cdsc=0
+ cdscb=0
+ cdscd=0
+ cf=0
+ cgbo=1e-013
+ cgdl=1e-010
+ cgdo=1e-010
+ cgidl=0.5
+ cgsl=1e-010
+ cgso=1e-010
+ cit=0
+ cjs=0.00096797
+ cjswgs=5.9903e-010
+ cjsws=1.5663e-010
+ ckappad=0.6
+ ckappas=0.6
+ clc=1e-007
+ cle=0.6
+ delta=0.0027272727
+ diomod=1
+ dlc=0
+ dlcig=1.5e-007
+ dmcg=1.5e-007
+ drout=0.56
+ dsub=0.5
+ dvt0=0
+ dvt0w=0
+ dvt1=0.53
+ dvt1w=0
+ dvt2=0
+ dvt2w=0
+ dvtp0=0
+ dvtp1=0
+ dwb=0
+ dwc=0
+ dwg=0
+ ef=0.95
+ egidl=0.8
+ em=4.1e+007
+ epsrox=3.9
+ eta0=0.75
+ etab=-0.32
+ eu=1.67
+ fnoimod=1
+ fprout=0
+ geomod=0
+ igbmod=0
+ igcmod=0
+ ijthsfwd=0.1
+ ijthsrev=0.1
+ jss=2.2959e-007
+ jswgs=0
+ jsws=2.1207e-013
+ k1=0.79418892
+ k2=-0.0057236965
+ k3=0
+ k3b=0
+ keta=-0.021025909
+ kt1=-0.33923366
+ kt1l=0
+ kt2=-0.021803571
+ ku0=0
+ kvsat=0
+ kvth0=0
+ la0=-7.4559545e-007
+ lags=1.3402325e-007
+ lalpha0=-1.0329047e-010
+ lbeta0=-3.7206623e-006
+ ldelta=2.7272727e-009
+ level=54
+ lint=0
+ lk1=-3.5489221e-008
+ lk2=-4.6356351e-009
+ lketa=-3.7690909e-008
+ lkt1=-5.0663377e-008
+ lkt2=-6.3214286e-009
+ ll=0
+ lln=1
+ lmax=1e-005
+ lmin=1.2e-006
+ lpclm=2.9060649e-008
+ lpdiblc2=1.7686364e-009
+ lpe0=1.1e-007
+ lpeb=0
+ ltvoff=0
+ lu0=-1.4308442e-009
+ lua=2.1903156e-016
+ lub=-6.4298182e-025
+ lub1=7.0824935e-025
+ luc=-1.4633922e-017
+ luc1=-5.0024338e-017
+ lute=3.448052e-007
+ lvoff=1.3159091e-008
+ lvth0=1.325026e-008
+ lw=0
+ lwl=0
+ lwn=1
+ minv=-0.25
+ mjs=0.32071
+ mjswgs=0.32059
+ mjsws=0.1
+ mobmod=0
+ moin=15
+ ndep=3e+017
+ nfactor=1
+ ngate=6e+019
+ njs=1.01
+ noff=2
+ noia='nfet_03v3_noia'
+ noib='nfet_03v3_noib'
+ noic='nfet_03v3_noic'
+ nsd=1e+020
+ ntnoi=1
+ pags=6.3697932e-014
+ palpha0=-1.0548281e-019
+ paramchk=1
+ pbeta0=-2.9791169e-014
+ pbs=0.70172
+ pbswgs=0.74743
+ pbsws=0.8062
+ pclm=0.22708279
+ pdiblc1=0.39
+ pdiblc2=0.00064013636
+ pdiblcb=0.2
+ pdits=0
+ pditsd=0
+ pditsl=0
+ permod=1
+ phin=0.07
+ pk1=-8.3746286e-015
+ pk2=2.7051485e-015
+ pkt1=2.4318421e-014
+ pkt2=3.0342857e-015
+ ppclm=1.9242888e-014
+ prt=0
+ prwb=0
+ prwg=0
+ pscbe1=6.6469e+008
+ pscbe2=1.638e-005
+ ptvoff=0
+ pu0=1.3295688e-015
+ pua=8.5070338e-024
+ pub=8.4187636e-032
+ pub1=-5.7827969e-031
+ puc=5.071119e-024
+ puc1=2.4011682e-023
+ pute=-1.6550649e-013
+ pvag=0
+ pvth0=-1.1596488e-014
+ rbodymod=0
+ rdsmod=0
+ rdsw=530
+ rdswmin=50
+ rdwmin=0
+ rgatemod=0
+ rsh=7
+ rswmin=0
+ saref=4.4e-007
+ sbref=4.4e-007
+ tcj=0.0009438
+ tcjsw=0.00060474
+ tcjswg=0.001
+ tnoimod=0
+ tnom=25
+ toxe=8e-009
+ toxm=8e-009
+ toxp=8e-009
+ toxref=8e-009
+ tpb=0.0018129
+ tpbsw=5e-005
+ tpbswg=0.0016872
+ trnqsmod=0
+ tvoff=0.001
+ u0=0.036490513
+ ua=-7.881063e-010
+ ua1=1.675e-009
+ ub=3.0594896e-018
+ ub1=-3.5465249e-018
+ uc=9.7557278e-011
+ uc1=-5.0997566e-011
+ ute=-1.7216234
+ vbm=-3
+ version=4.5
+ vfbcv=-1
+ voff=-0.12197591
+ voffcv=0.005
+ voffl=0
+ vsat=85000
+ vth0=0.64923469
+ w0=5e-007
+ wags=-1.501953e-008
+ walpha0=1.0548281e-014
+ wbeta0=1.9555512e-007
+ wint=1e-008
+ wk1=8.3746286e-010
+ wk2=-2.005398e-009
+ wkt1=-2.4318421e-009
+ wkt2=5.0571429e-010
+ wl=0
+ wln=1
+ wmax=1.2e-006
+ wmin=5e-007
+ wpclm=-1.603574e-008
+ wr=1
+ wtvoff=0
+ wu0=-1.2698026e-009
+ wua=-7.0891948e-018
+ wub=-1.6806265e-025
+ wub1=5.1661197e-025
+ wuc=-8.460177e-018
+ wuc1=-2.4011682e-018
+ wute=1.7837922e-007
+ wvth0=-4.067414e-009
+ ww=0
+ wwl=0
+ wwn=1
+ xj=1e-007
+ xl=0
+ xpart=0
+ xtis=3
+ xw=0
.model nfet_03v3.7 nmos
+ a0=1.1588
+ a1=0
+ a2=1
+ acde=0.6
+ acnqsmod=0
+ agidl=1.3268e-010
+ ags=0.29711029
+ alpha0=8.0592e-005
+ alpha1=0
+ at=23000
+ b0=0
+ b1=0
+ beta0=23.6678
+ bgidl=1.8961e+009
+ binunit=2
+ capmod=2
+ cdsc=0
+ cdscb=0
+ cdscd=0
+ cf=0
+ cgbo=1e-013
+ cgdl=1e-010
+ cgdo=1e-010
+ cgidl=0.5
+ cgsl=1e-010
+ cgso=1e-010
+ cit=0
+ cjs=0.00096797
+ cjswgs=5.9903e-010
+ cjsws=1.5663e-010
+ ckappad=0.6
+ ckappas=0.6
+ clc=1e-007
+ cle=0.6
+ delta=0.003
+ diomod=1
+ dlc=0
+ dlcig=1.5e-007
+ dmcg=1.5e-007
+ drout=0.56
+ dsub=0.5
+ dvt0=0
+ dvt0w=0
+ dvt1=0.53
+ dvt1w=0
+ dvt2=0
+ dvt2w=0
+ dvtp0=0
+ dvtp1=0
+ dwb=0
+ dwc=0
+ dwg=0
+ ef=0.95
+ egidl=0.8
+ em=4.1e+007
+ epsrox=3.9
+ eta0=0.75
+ etab=-0.32
+ eu=1.67
+ fnoimod=1
+ fprout=0
+ geomod=0
+ igbmod=0
+ igcmod=0
+ ijthsfwd=0.1
+ ijthsrev=0.1
+ jss=2.2959e-007
+ jswgs=0
+ jsws=2.1207e-013
+ k1=0.79064
+ k2=-0.00618726
+ k3=0
+ k3b=0
+ keta=-0.024795
+ kt1=-0.3443
+ kt1l=0
+ kt2=-0.022435714
+ ku0=0
+ kvsat=0
+ kvth0=0
+ level=54
+ lint=0
+ ll=0
+ lln=1
+ lmax=5.0001e-005
+ lmin=1e-005
+ lpe0=1.1e-007
+ lpeb=0
+ ltvoff=0
+ lw=0
+ lwl=0
+ lwn=1
+ minv=-0.25
+ mjs=0.32071
+ mjswgs=0.32059
+ mjsws=0.1
+ mobmod=0
+ moin=15
+ ndep=3e+017
+ nfactor=1
+ ngate=6e+019
+ njs=1.01
+ noff=2
+ noia='nfet_03v3_noia'
+ noib='nfet_03v3_noib'
+ noic='nfet_03v3_noic'
+ nsd=1e+020
+ ntnoi=1
+ paramchk=1
+ pbs=0.70172
+ pbswgs=0.74743
+ pbsws=0.8062
+ pclm=0.22998886
+ pdiblc1=0.39
+ pdiblc2=0.000817
+ pdiblcb=0.2
+ pdits=0
+ pditsd=0
+ pditsl=0
+ permod=1
+ phin=0.07
+ prt=0
+ prwb=0
+ prwg=0
+ pscbe1=6.6469e+008
+ pscbe2=1.638e-005
+ ptvoff=0
+ pvag=0
+ rbodymod=0
+ rdsmod=0
+ rdsw=530
+ rdswmin=50
+ rdwmin=0
+ rgatemod=0
+ rsh=7
+ rswmin=0
+ saref=4.4e-007
+ sbref=4.4e-007
+ tcj=0.0009438
+ tcjsw=0.00060474
+ tcjswg=0.001
+ tnoimod=0
+ tnom=25
+ toxe=8e-009
+ toxm=8e-009
+ toxp=8e-009
+ toxref=8e-009
+ tpb=0.0018129
+ tpbsw=5e-005
+ tpbswg=0.0016872
+ trnqsmod=0
+ tvoff=0.001
+ u0=0.036347429
+ ua=-7.6620314e-010
+ ua1=1.675e-009
+ ub=2.9951914e-018
+ ub1=-3.4757e-018
+ uc=9.6093886e-011
+ uc1=-5.6e-011
+ ute=-1.6871429
+ vbm=-3
+ version=4.5
+ vfbcv=-1
+ voff=-0.12066
+ voffcv=0.005
+ voffl=0
+ vsat=85000
+ vth0=0.65055971
+ w0=5e-007
+ wags=-8.6497371e-009
+ wbeta0=1.92576e-007
+ wint=1e-008
+ wk2=-1.7348832e-009
+ wkt2=8.0914286e-010
+ wl=0
+ wln=1
+ wmax=1.2e-006
+ wmin=5e-007
+ wpclm=-1.4111451e-008
+ wr=1
+ wtvoff=0
+ wu0=-1.1368457e-009
+ wua=-6.2384914e-018
+ wub=-1.5964389e-025
+ wub1=4.58784e-025
+ wuc=-7.9530651e-018
+ wute=1.6182857e-007
+ wvth0=-5.2270629e-009
+ ww=0
+ wwl=0
+ wwn=1
+ xj=1e-007
+ xl=0
+ xpart=0
+ xtis=3
+ xw=0
.model nfet_03v3.8 nmos
+ a0=0.10362636
+ a1=0
+ a2=1
+ acde=0.6
+ acnqsmod=0
+ agidl=1.3268e-010
+ ags=0.2705431
+ alpha0=2.5953123e-006
+ alpha1=0
+ at=23000
+ b0=0
+ b1=0
+ beta0=21.140586
+ bgidl=1.8961e+009
+ binunit=2
+ capmod=2
+ cdsc=0
+ cdscb=0
+ cdscd=0
+ cf=0
+ cgbo=1e-013
+ cgdl=1e-010
+ cgdo=1e-010
+ cgidl=0.5
+ cgsl=1e-010
+ cgso=1e-010
+ cit=0
+ cjs=0.00096797
+ cjswgs=5.9903e-010
+ cjsws=1.5663e-010
+ ckappad=0.6
+ ckappas=0.6
+ clc=1e-007
+ cle=0.6
+ delta=0.0036363636
+ diomod=1
+ dlc=0
+ dlcig=1.5e-007
+ dmcg=1.5e-007
+ drout=0.56
+ dsub=0.5
+ dvt0=0
+ dvt0w=0
+ dvt1=0.53
+ dvt1w=0
+ dvt2=0
+ dvt2w=0
+ dvtp0=0
+ dvtp1=0
+ dwb=0
+ dwc=0
+ dwg=0
+ ef=0.95
+ egidl=0.8
+ em=4.1e+007
+ epsrox=3.9
+ eta0=0.75
+ etab=-0.32
+ eu=1.67
+ fnoimod=1
+ fprout=0
+ geomod=0
+ igbmod=0
+ igcmod=0
+ ijthsfwd=0.1
+ ijthsrev=0.1
+ jss=2.2959e-007
+ jswgs=0
+ jsws=2.1207e-013
+ k1=0.95060511
+ k2=0.013945175
+ k3=0
+ k3b=0
+ keta=-0.12424077
+ kt1=-0.28115299
+ kt1l=0
+ kt2=-0.025449687
+ ku0=0
+ kvsat=0
+ kvth0=0
+ la0=-8.0818182e-010
+ lags=3.2753448e-008
+ lalpha0=-2.5435614e-013
+ ldelta=3.1818182e-009
+ level=54
+ lint=0
+ lk1=-9.5597554e-008
+ lk2=-3.0232209e-008
+ lketa=2.9920384e-008
+ lkt1=-1.0099496e-008
+ lkt2=9.6575269e-010
+ ll=0
+ lln=1
+ lmax=5e-007
+ lmin=2.8e-007
+ lnoff=1.2990496e-006
+ lpclm=-9.798626e-009
+ lpe0=1.1e-007
+ lpeb=0
+ ltvoff=0
+ lu0=1.7050207e-010
+ lua=2.5458994e-016
+ lub=-3.3240512e-025
+ lub1=4.827456e-025
+ luc=-6.8059408e-017
+ luc1=4.973267e-017
+ lvoff=6.8691116e-010
+ lvoffcv=-1.118626e-007
+ lvsat=-0.00034132231
+ lvth0=-5.5747725e-008
+ lw=0
+ lwl=0
+ lwn=1
+ minv=-0.25
+ mjs=0.32071
+ mjswgs=0.32059
+ mjsws=0.1
+ mobmod=0
+ moin=15
+ ndep=3e+017
+ nfactor=1
+ ngate=6e+019
+ njs=1.01
+ noff=-0.59809917
+ noia='nfet_03v3_noia'
+ noib='nfet_03v3_noib'
+ noic='nfet_03v3_noic'
+ nsd=1e+020
+ ntnoi=1
+ pags=-6.6365124e-014
+ palpha0=-5.7142305e-020
+ paramchk=1
+ pbs=0.70172
+ pbswgs=0.74743
+ pbsws=0.8062
+ pclm=0.20476889
+ pdiblc1=0.39
+ pdiblc2=0.003171
+ pdiblcb=0.2
+ pdits=0
+ pditsd=0
+ pditsl=0
+ permod=1
+ phin=0.07
+ pk1=-5.177723e-015
+ pk2=-5.4442735e-015
+ pketa=2.0847148e-015
+ pkt1=3.5188078e-014
+ pkt2=-3.1602845e-015
+ pnoff=-1.5328785e-012
+ ppclm=-5.8632603e-014
+ prt=0
+ prwb=0
+ prwg=0
+ pscbe1=6.6469e+008
+ pscbe2=1.638e-005
+ ptvoff=0
+ pu0=4.1983839e-015
+ pua=1.7471409e-022
+ pub=4.2239319e-032
+ pub1=-3.1500653e-031
+ puc=3.2259428e-023
+ puc1=-5.8684551e-023
+ pvag=0
+ pvoff=-6.8553733e-015
+ pvoffcv=1.3199787e-013
+ pvsat=3.4063967e-009
+ pvth0=1.824977e-014
+ rbodymod=0
+ rdsmod=0
+ rdsw=530
+ rdswmin=50
+ rdwmin=0
+ rgatemod=0
+ rsh=7
+ rswmin=0
+ saref=4.4e-007
+ sbref=4.4e-007
+ tcj=0.0009438
+ tcjsw=0.00060474
+ tcjswg=0.001
+ tnoimod=0
+ tnom=25
+ toxe=8e-009
+ toxm=8e-009
+ toxp=8e-009
+ toxref=8e-009
+ tpb=0.0018129
+ tpbsw=5e-005
+ tpbswg=0.0016872
+ trnqsmod=0
+ tvoff=0.001
+ u0=0.046898182
+ ua=-6.6207759e-010
+ ua1=1.675e-009
+ ub=3.7962141e-018
+ ub1=-5.3788142e-018
+ uc=2.9436835e-010
+ uc1=-2.2938539e-010
+ ute=-1.5701136
+ vbm=-3
+ version=4.5
+ vfbcv=-1
+ voff=-0.12424632
+ voffcv=0.22872521
+ voffl=0
+ vsat=85682.645
+ vth0=0.75419347
+ w0=5e-007
+ wags=1.3273025e-007
+ walpha0=1.1428461e-013
+ wbeta0=-5.6473191e-007
+ wint=1e-008
+ wk1=1.0355446e-008
+ wk2=1.9443834e-008
+ wketa=-4.1694295e-009
+ wkt1=-1.2105482e-007
+ wkt2=8.9970236e-009
+ wl=0
+ wln=1
+ wmax=1e-005
+ wmin=1.2e-006
+ wnoff=3.065757e-006
+ wpclm=2.8042187e-007
+ wr=1
+ wtvoff=0
+ wu0=-1.6262868e-008
+ wua=5.6335718e-017
+ wub=-1.6693412e-024
+ wub1=2.1072821e-024
+ wuc=-1.6002278e-016
+ wuc1=2.0459475e-016
+ wute=2.0073409e-007
+ wvoff=3.5791497e-008
+ wvoffcv=-2.6399574e-007
+ wvsat=-0.0068127934
+ wvth0=-5.7737207e-008
+ ww=0
+ wwl=0
+ wwn=1
+ xj=1e-007
+ xl=0
+ xpart=0
+ xtis=3
+ xw=0
.model nfet_03v3.9 nmos
+ a0=0.57970277
+ a1=0
+ a2=1
+ acde=0.6
+ acnqsmod=0
+ agidl=1.3268e-010
+ ags=0.63340774
+ alpha0=6.7040286e-006
+ alpha1=0
+ at=23000
+ b0=0
+ b1=0
+ beta0=21.043581
+ bgidl=1.8961e+009
+ binunit=2
+ capmod=2
+ cdsc=0
+ cdscb=0
+ cdscd=0
+ cf=0
+ cgbo=1e-013
+ cgdl=1e-010
+ cgdo=1e-010
+ cgidl=0.5
+ cgsl=1e-010
+ cgso=1e-010
+ cit=0
+ cjs=0.00096797
+ cjswgs=5.9903e-010
+ cjsws=1.5663e-010
+ ckappad=0.6
+ ckappas=0.6
+ clc=1e-007
+ cle=0.6
+ delta=0.0014285714
+ diomod=1
+ dlc=0
+ dlcig=1.5e-007
+ dmcg=1.5e-007
+ drout=0.56
+ dsub=0.5
+ dvt0=0
+ dvt0w=0
+ dvt1=0.53
+ dvt1w=0
+ dvt2=0
+ dvt2w=0
+ dvtp0=0
+ dvtp1=0
+ dwb=0
+ dwc=0
+ dwg=0
+ ef=0.95
+ egidl=0.8
+ em=4.1e+007
+ epsrox=3.9
+ eta0=0.75
+ etab=-0.32
+ eu=1.67
+ fnoimod=1
+ fprout=0
+ geomod=0
+ igbmod=0
+ igcmod=0
+ ijthsfwd=0.1
+ ijthsrev=0.1
+ jss=2.2959e-007
+ jswgs=0
+ jsws=2.1207e-013
+ k1=0.75941
+ k2=0.017155231
+ k3=0
+ k3b=0
+ keta=-0.043888571
+ kt1=-0.30297354
+ kt1l=0
+ kt2=-0.021799026
+ ku0=0
+ kvsat=0
+ kvth0=0
+ la0=-2.3884638e-007
+ lags=-1.4867887e-007
+ lalpha0=-2.3087143e-012
+ lbeta0=4.8502597e-008
+ ldelta=4.2857143e-009
+ level=54
+ lint=0
+ lk2=-3.1837237e-008
+ lketa=-1.0255714e-008
+ lkt1=8.1077922e-010
+ lkt2=-8.5957792e-010
+ ll=0
+ lln=1
+ lmax=1.2e-006
+ lmin=5e-007
+ lpclm=6.8726318e-008
+ lpdiblc2=9.06e-010
+ lpe0=1.1e-007
+ lpeb=0
+ ltvoff=0
+ lu0=4.387089e-009
+ lua=3.880134e-016
+ lub=-1.7056325e-025
+ lub1=-6.899552e-025
+ luc=5.1261039e-019
+ luc1=7.5986727e-018
+ lvoff=-1.0167857e-008
+ lvth0=-9.953513e-009
+ lw=0
+ lwl=0
+ lwn=1
+ minv=-0.25
+ mjs=0.32071
+ mjswgs=0.32059
+ mjsws=0.1
+ mobmod=0
+ moin=15
+ ndep=3e+017
+ nfactor=1
+ ngate=6e+019
+ njs=1.01
+ noff=2
+ noia='nfet_03v3_noia'
+ noib='nfet_03v3_noib'
+ noic='nfet_03v3_noic'
+ nsd=1e+020
+ ntnoi=1
+ pa0=-2.3401007e-013
+ pags=8.279421e-014
+ paramchk=1
+ pbeta0=-4.8405592e-013
+ pbs=0.70172
+ pbswgs=0.74743
+ pbsws=0.8062
+ pclm=0.047719
+ pdiblc1=0.39
+ pdiblc2=0.001359
+ pdiblcb=0.2
+ pdits=0
+ pditsd=0
+ pditsl=0
+ permod=1
+ phin=0.07
+ pk2=7.3331031e-015
+ pkt1=2.1335166e-014
+ pkt2=4.3014448e-015
+ ppclm=-8.1325983e-015
+ prt=0
+ prwb=0
+ prwg=0
+ pscbe1=6.6469e+008
+ pscbe2=1.638e-005
+ ptvoff=0
+ pu0=2.9708645e-016
+ pua=3.4779762e-022
+ pub=-4.5859137e-031
+ pub1=5.7696713e-031
+ puc=-5.1158517e-024
+ puc1=1.3044275e-023
+ pvag=0
+ pvoff=1.8926357e-014
+ pvth0=-1.2468455e-014
+ rbodymod=0
+ rdsmod=0
+ rdsw=530
+ rdswmin=50
+ rdwmin=0
+ rgatemod=0
+ rsh=7
+ rswmin=0
+ saref=4.4e-007
+ sbref=4.4e-007
+ tcj=0.0009438
+ tcjsw=0.00060474
+ tcjswg=0.001
+ tnoimod=0
+ tnom=25
+ toxe=8e-009
+ toxm=8e-009
+ toxp=8e-009
+ toxref=8e-009
+ tpb=0.0018129
+ tpbsw=5e-005
+ tpbswg=0.0016872
+ trnqsmod=0
+ tvoff=0.001
+ u0=0.038465008
+ ua=-9.289245e-010
+ ua1=1.675e-009
+ ub=3.4725304e-018
+ ub1=-3.0334126e-018
+ uc=1.5722431e-010
+ uc1=-1.4511739e-010
+ ute=-1.5701136
+ vbm=-3
+ version=4.5
+ vfbcv=-1
+ voff=-0.10253679
+ voffcv=0.005
+ voffl=0
+ vsat=85000
+ vth0=0.66260505
+ w0=5e-007
+ wa0=4.6802014e-007
+ wags=-1.6558842e-007
+ wbeta0=4.0337993e-007
+ wint=1e-008
+ wk2=-6.1109193e-009
+ wkt1=-9.3348999e-008
+ wkt2=-5.9264351e-009
+ wl=0
+ wln=1
+ wmax=1e-005
+ wmin=1.2e-006
+ wpclm=1.7942187e-007
+ wr=1
+ wtvoff=0
+ wu0=-8.4602728e-009
+ wua=-2.8983135e-016
+ wub=-6.6767982e-025
+ wub1=3.2333483e-025
+ wuc=-8.5272224e-017
+ wuc1=6.1137104e-017
+ wute=2.0073409e-007
+ wvoff=-1.5771964e-008
+ wvth0=3.6992425e-009
+ ww=0
+ wwl=0
+ wwn=1
+ xj=1e-007
+ xl=0
+ xpart=0
+ xtis=3
+ xw=0
.model nfet_03v3.10 nmos
+ a0=1.175342
+ a1=0
+ a2=1
+ acde=0.6
+ acnqsmod=0
+ agidl=1.3268e-010
+ ags=0.26729169
+ alpha0=9.0929986e-005
+ alpha1=0
+ at=23000
+ b0=0
+ b1=0
+ beta0=24.512311
+ bgidl=1.8961e+009
+ binunit=2
+ capmod=2
+ cdsc=0
+ cdscb=0
+ cdscd=0
+ cf=0
+ cgbo=1e-013
+ cgdl=1e-010
+ cgdo=1e-010
+ cgidl=0.5
+ cgsl=1e-010
+ cgso=1e-010
+ cit=0
+ cjs=0.00096797
+ cjswgs=5.9903e-010
+ cjsws=1.5663e-010
+ ckappad=0.6
+ ckappas=0.6
+ clc=1e-007
+ cle=0.6
+ delta=0.0027272727
+ diomod=1
+ dlc=0
+ dlcig=1.5e-007
+ dmcg=1.5e-007
+ drout=0.56
+ dsub=0.5
+ dvt0=0
+ dvt0w=0
+ dvt1=0.53
+ dvt1w=0
+ dvt2=0
+ dvt2w=0
+ dvtp0=0
+ dvtp1=0
+ dwb=0
+ dwc=0
+ dwg=0
+ ef=0.95
+ egidl=0.8
+ em=4.1e+007
+ epsrox=3.9
+ eta0=0.75
+ etab=-0.32
+ eu=1.67
+ fnoimod=1
+ fprout=0
+ geomod=0
+ igbmod=0
+ igcmod=0
+ ijthsfwd=0.1
+ ijthsrev=0.1
+ jss=2.2959e-007
+ jswgs=0
+ jsws=2.1207e-013
+ k1=0.79747612
+ k2=-0.0074231864
+ k3=0
+ k3b=0
+ keta=-0.021025909
+ kt1=-0.31506405
+ kt1l=0
+ kt2=-0.016812862
+ ku0=0
+ kvsat=0
+ kvth0=0
+ la0=-9.536135e-007
+ lags=2.9066039e-007
+ lalpha0=-1.0337986e-010
+ lbeta0=-4.1139731e-006
+ ldelta=2.7272727e-009
+ level=54
+ lint=0
+ lk1=-4.5679339e-008
+ lk2=-2.3431364e-009
+ lketa=-3.7690909e-008
+ lkt1=1.5319401e-008
+ lkt2=-6.8429752e-009
+ ll=0
+ lln=1
+ lmax=1e-005
+ lmin=1.2e-006
+ lnoff=-1.5464876e-007
+ lpclm=-1.5414418e-007
+ lpdiblc2=1.7686364e-009
+ lpe0=1.1e-007
+ lpeb=0
+ ltvoff=0
+ lu0=1.9522345e-009
+ lua=2.4617513e-016
+ lua1=2.5980992e-017
+ lub=1.6897655e-025
+ lub1=-1.7520434e-024
+ luc=6.3987831e-017
+ luc1=-1.1288886e-016
+ lute=-2.7427686e-008
+ lvoff=1.3159091e-008
+ lvoffcv=8.5056818e-008
+ lvth0=7.3817355e-009
+ lw=0
+ lwl=0
+ lwn=1
+ minv=-0.25
+ mjs=0.32071
+ mjswgs=0.32059
+ mjsws=0.1
+ mobmod=0
+ moin=15
+ ndep=3e+017
+ nfactor=1
+ ngate=6e+019
+ njs=1.01
+ noff=2.128874
+ noia='nfet_03v3_noia'
+ noib='nfet_03v3_noib'
+ noic='nfet_03v3_noic'
+ nsd=1e+020
+ ntnoi=1
+ pa0=2.454613e-013
+ pags=-1.211339e-013
+ paramchk=1
+ pbeta0=4.3431558e-013
+ pbs=0.70172
+ pbswgs=0.74743
+ pbsws=0.8062
+ pclm=0.23344442
+ pdiblc1=0.39
+ pdiblc2=0.00064013636
+ pdiblcb=0.2
+ pdits=0
+ pditsd=0
+ pditsl=0
+ permod=1
+ phin=0.07
+ pk1=3.6497107e-015
+ pkt1=-5.3541257e-014
+ pkt2=3.6497107e-015
+ pnoff=1.8248554e-013
+ ppclm=2.3542459e-013
+ prt=0
+ prwb=0
+ prwg=0
+ pscbe1=6.6469e+008
+ pscbe2=1.638e-005
+ ptvoff=0
+ pu0=-2.662464e-015
+ pua=-2.3522386e-023
+ pua1=-3.065757e-023
+ pub=-8.7392324e-031
+ pub1=2.3248657e-030
+ puc=-8.7702549e-023
+ puc1=9.8191818e-023
+ pute=2.7372831e-013
+ pvag=0
+ pvoffcv=-1.0036705e-013
+ pvth0=-4.6716298e-015
+ rbodymod=0
+ rdsmod=0
+ rdsw=530
+ rdswmin=50
+ rdwmin=0
+ rgatemod=0
+ rsh=7
+ rswmin=0
+ saref=4.4e-007
+ sbref=4.4e-007
+ tcj=0.0009438
+ tcjsw=0.00060474
+ tcjswg=0.001
+ tnoimod=0
+ tnom=25
+ toxe=8e-009
+ toxm=8e-009
+ toxp=8e-009
+ toxref=8e-009
+ tpb=0.0018129
+ tpbsw=5e-005
+ tpbswg=0.0016872
+ trnqsmod=0
+ tvoff=0.001
+ u0=0.040494054
+ ua=-8.1072595e-010
+ ua1=1.6533492e-009
+ ub=3.1895805e-018
+ ub1=-2.1483391e-018
+ uc=1.0432829e-010
+ uc1=-4.4711114e-011
+ ute=-1.5472572
+ vbm=-3
+ version=4.5
+ vfbcv=-1
+ voff=-0.12197591
+ voffcv=-0.065880682
+ voffl=0
+ vsat=85000
+ vth0=0.64815901
+ w0=5e-007
+ wa0=6.8460666e-008
+ wags=4.3516718e-009
+ wbeta0=-3.6192965e-007
+ wint=1e-008
+ wk1=-3.0414256e-009
+ wkt1=-3.095198e-008
+ wkt2=-5.3833233e-009
+ wl=0
+ wln=1
+ wmax=1e-005
+ wmin=1.2e-006
+ wnoff=-1.5207128e-007
+ wpclm=-2.3542459e-008
+ wr=1
+ wtvoff=0
+ wu0=-5.9939808e-009
+ wua=1.9601988e-017
+ wua1=2.5547975e-017
+ wub=-3.2156993e-025
+ wub1=-1.1332474e-024
+ wuc=-1.6449976e-017
+ wuc1=-9.8191818e-018
+ wute=-2.7372831e-008
+ wvoffcv=8.3639205e-008
+ wvth0=-2.7981116e-009
+ ww=0
+ wwl=0
+ wwn=1
+ xj=1e-007
+ xl=0
+ xpart=0
+ xtis=3
+ xw=0
.model nfet_03v3.11 nmos
+ a0=1.0799807
+ a1=0
+ a2=1
+ acde=0.6
+ acnqsmod=0
+ agidl=1.3268e-010
+ ags=0.29635773
+ alpha0=8.0592e-005
+ alpha1=0
+ at=23000
+ b0=0
+ b1=0
+ beta0=24.100914
+ bgidl=1.8961e+009
+ binunit=2
+ capmod=2
+ cdsc=0
+ cdscb=0
+ cdscd=0
+ cf=0
+ cgbo=1e-013
+ cgdl=1e-010
+ cgdo=1e-010
+ cgidl=0.5
+ cgsl=1e-010
+ cgso=1e-010
+ cit=0
+ cjs=0.00096797
+ cjswgs=5.9903e-010
+ cjsws=1.5663e-010
+ ckappad=0.6
+ ckappas=0.6
+ clc=1e-007
+ cle=0.6
+ delta=0.003
+ diomod=1
+ dlc=0
+ dlcig=1.5e-007
+ dmcg=1.5e-007
+ drout=0.56
+ dsub=0.5
+ dvt0=0
+ dvt0w=0
+ dvt1=0.53
+ dvt1w=0
+ dvt2=0
+ dvt2w=0
+ dvtp0=0
+ dvtp1=0
+ dwb=0
+ dwc=0
+ dwg=0
+ ef=0.95
+ egidl=0.8
+ em=4.1e+007
+ epsrox=3.9
+ eta0=0.75
+ etab=-0.32
+ eu=1.67
+ fnoimod=1
+ fprout=0
+ geomod=0
+ igbmod=0
+ igcmod=0
+ ijthsfwd=0.1
+ ijthsrev=0.1
+ jss=2.2959e-007
+ jswgs=0
+ jsws=2.1207e-013
+ k1=0.79290818
+ k2=-0.0076575
+ k3=0
+ k3b=0
+ keta=-0.024795
+ kt1=-0.31353211
+ kt1l=0
+ kt2=-0.017497159
+ ku0=0
+ kvsat=0
+ kvth0=0
+ level=54
+ lint=0
+ ll=0
+ lln=1
+ lmax=5.0001e-005
+ lmin=1e-005
+ lpe0=1.1e-007
+ lpeb=0
+ ltvoff=0
+ lw=0
+ lwl=0
+ lwn=1
+ minv=-0.25
+ mjs=0.32071
+ mjswgs=0.32059
+ mjsws=0.1
+ mobmod=0
+ moin=15
+ ndep=3e+017
+ nfactor=1
+ ngate=6e+019
+ njs=1.01
+ noff=2.1134091
+ noia='nfet_03v3_noia'
+ noib='nfet_03v3_noib'
+ noic='nfet_03v3_noic'
+ nsd=1e+020
+ ntnoi=1
+ paramchk=1
+ pbs=0.70172
+ pbswgs=0.74743
+ pbsws=0.8062
+ pclm=0.21803
+ pdiblc1=0.39
+ pdiblc2=0.000817
+ pdiblcb=0.2
+ pdits=0
+ pditsd=0
+ pditsl=0
+ permod=1
+ phin=0.07
+ prt=0
+ prwb=0
+ prwg=0
+ pscbe1=6.6469e+008
+ pscbe2=1.638e-005
+ ptvoff=0
+ pvag=0
+ rbodymod=0
+ rdsmod=0
+ rdsw=530
+ rdswmin=50
+ rdwmin=0
+ rgatemod=0
+ rsh=7
+ rswmin=0
+ saref=4.4e-007
+ sbref=4.4e-007
+ tcj=0.0009438
+ tcjsw=0.00060474
+ tcjswg=0.001
+ tnoimod=0
+ tnom=25
+ toxe=8e-009
+ toxm=8e-009
+ toxp=8e-009
+ toxref=8e-009
+ tpb=0.0018129
+ tpbsw=5e-005
+ tpbswg=0.0016872
+ trnqsmod=0
+ tvoff=0.001
+ u0=0.040689277
+ ua=-7.8610843e-010
+ ua1=1.6559473e-009
+ ub=3.2064782e-018
+ ub1=-2.3235434e-018
+ uc=1.1072708e-010
+ uc1=-5.6e-011
+ ute=-1.55
+ vbm=-3
+ version=4.5
+ vfbcv=-1
+ voff=-0.12066
+ voffcv=-0.057375
+ voffl=0
+ vsat=85000
+ vth0=0.64889718
+ w0=5e-007
+ wa0=9.3006796e-008
+ wags=-7.7617182e-009
+ wbeta0=-3.1849809e-007
+ wint=1e-008
+ wk1=-2.6764545e-009
+ wkt1=-3.6306106e-008
+ wkt2=-5.0183523e-009
+ wl=0
+ wln=1
+ wmax=1e-005
+ wmin=1.2e-006
+ wnoff=-1.3382273e-007
+ wr=1
+ wtvoff=0
+ wu0=-6.2602272e-009
+ wua=1.7249749e-017
+ wua1=2.2482218e-017
+ wub=-4.0896225e-025
+ wub1=-9.0076078e-025
+ wuc=-2.5220231e-017
+ wvoffcv=7.36025e-008
+ wvth0=-3.2652745e-009
+ ww=0
+ wwl=0
+ wwn=1
+ xj=1e-007
+ xl=0
+ xpart=0
+ xtis=3
+ xw=0
.model nfet_03v3.12 nmos
+ a0=0.13211844
+ a1=0
+ a2=1
+ acde=0.6
+ acnqsmod=0
+ agidl=1.3268e-010
+ ags=0.46155061
+ alpha0=2.6067636e-006
+ alpha1=0
+ at=23000
+ b0=0
+ b1=0
+ beta0=21.084
+ bgidl=1.8961e+009
+ binunit=2
+ capmod=2
+ cdsc=0
+ cdscb=0
+ cdscd=0
+ cf=0
+ cgbo=1e-013
+ cgdl=1e-010
+ cgdo=2.3e-010
+ cgidl=0.5
+ cgsl=1e-010
+ cgso=2.3e-010
+ cit=0
+ cjs=0.00096797
+ cjswgs=5.9903e-010
+ cjsws=1.5663e-010
+ ckappad=0.6
+ ckappas=0.6
+ clc=1e-007
+ cle=0.6
+ delta=0.0036363636
+ diomod=1
+ dlc=3e-008
+ dlcig=1.5e-007
+ dmcg=1.5e-007
+ drout=0.56
+ dsub=0.5
+ dvt0=0
+ dvt0w=0
+ dvt1=0.53
+ dvt1w=0
+ dvt2=0
+ dvt2w=0
+ dvtp0=0
+ dvtp1=0
+ dwb=0
+ dwc=0
+ dwg=0
+ ef=0.95
+ egidl=0.8
+ em=4.1e+007
+ epsrox=3.9
+ eta0=0.75
+ etab=-0.32
+ eu=1.67
+ fnoimod=1
+ fprout=0
+ geomod=0
+ igbmod=0
+ igcmod=0
+ ijthsfwd=0.1
+ ijthsrev=0.1
+ jss=2.2959e-007
+ jswgs=0
+ jsws=2.1207e-013
+ k1=0.95164273
+ k2=0.015893454
+ k3=0
+ k3b=0
+ keta=-0.12105603
+ kt1=-0.29328273
+ kt1l=0
+ kt2=-0.024548182
+ ku0=0
+ kvsat=0
+ kvth0=0
+ la0=-1.5054221e-008
+ lags=-6.2750307e-008
+ lalpha0=-2.6008182e-013
+ ldelta=3.1818182e-009
+ level=54
+ lint=0
+ lk1=-9.6116364e-008
+ lk2=-3.0777727e-008
+ lketa=2.8328017e-008
+ lkt1=-6.5736364e-009
+ lkt2=6.4909091e-010
+ ll=0
+ lln=1
+ lmax=5e-007
+ lmin=2.8e-007
+ lnoff=1.1454545e-006
+ lpclm=-1.5673636e-008
+ lpe0=1.1e-007
+ lpeb=0
+ ltvoff=0
+ lu0=5.9118182e-010
+ lua=2.7209636e-016
+ lub=-3.2817273e-025
+ lub1=4.5118182e-025
+ luc=-6.4827e-017
+ luc1=4.3852454e-017
+ lvoffcv=-9.8636364e-008
+ lvth0=-5.3919091e-008
+ lw=0
+ lwl=0
+ lwn=1
+ minv=-0.25
+ mjs=0.32071
+ mjswgs=0.32059
+ mjsws=0.1
+ mobmod=0
+ moin=15
+ ndep=3e+017
+ nfactor=1
+ ngate=6e+019
+ njs=1.01
+ noff=-0.29090909
+ noia='nfet_03v3_noia'
+ noib='nfet_03v3_noib'
+ noic='nfet_03v3_noic'
+ nsd=1e+020
+ ntnoi=1
+ pa0=1.4217547e-013
+ pags=8.8676235e-013
+ paramchk=1
+ pbs=0.70172
+ pbswgs=0.74743
+ pbsws=0.8062
+ pclm=0.23286727
+ pdiblc1=0.39
+ pdiblc2=0.003171
+ pdiblcb=0.2
+ pdits=0
+ pditsd=0
+ pditsl=0
+ permod=1
+ phin=0.07
+ pketa=1.7976533e-014
+ prt=0
+ prwb=0
+ prwg=0
+ pscbe1=6.6469e+008
+ pscbe2=1.638e-005
+ ptvoff=0
+ pvag=0
+ rbodymod=0
+ rdsmod=0
+ rdsw=530
+ rdswmin=50
+ rdwmin=0
+ rgatemod=0
+ rsh=7
+ rswmin=0
+ saref=4.4e-007
+ sbref=4.4e-007
+ tcj=0.0009438
+ tcjsw=0.00060474
+ tcjswg=0.001
+ tnoimod=0
+ tnom=25
+ toxe=8e-009
+ toxm=8e-009
+ toxp=8e-009
+ toxref=8e-009
+ tpb=0.0018129
+ tpbsw=5e-005
+ tpbswg=0.0016872
+ trnqsmod=0
+ tvoff=0.001
+ u0=0.045268636
+ ua=-6.5643273e-010
+ ua1=1.675e-009
+ ub=3.6289455e-018
+ ub1=-5.1676636e-018
+ uc=2.78334e-010
+ uc1=-2.0888491e-010
+ ute=-1.55
+ vbm=-3
+ version=4.5
+ vfbcv=-1
+ voff=-0.12066
+ voffcv=0.20227273
+ voffl=0
+ vsat=85000
+ vth0=0.74840818
+ w0=5e-007
+ wa0=-2.8435094e-007
+ wags=-1.7735247e-006
+ wint=1e-008
+ wketa=-3.5953066e-008
+ wl=0
+ wln=1
+ wmax=0.000100001
+ wmin=1e-005
+ wr=1
+ wtvoff=0
+ ww=0
+ wwl=0
+ wwn=1
+ xj=1e-007
+ xl=0
+ xpart=0
+ xtis=3
+ xw=0
.model nfet_03v3.13 nmos
+ a0=0.62659857
+ a1=0
+ a2=1
+ acde=0.6
+ acnqsmod=0
+ agidl=1.3268e-010
+ ags=0.61681571
+ alpha0=6.7040286e-006
+ alpha1=0
+ at=23000
+ b0=0
+ b1=0
+ beta0=21.084
+ bgidl=1.8961e+009
+ binunit=2
+ capmod=2
+ cdsc=0
+ cdscb=0
+ cdscd=0
+ cf=0
+ cgbo=1e-013
+ cgdl=1e-010
+ cgdo=1e-010
+ cgidl=0.5
+ cgsl=1e-010
+ cgso=1e-010
+ cit=0
+ cjs=0.00096797
+ cjswgs=5.9903e-010
+ cjsws=1.5663e-010
+ ckappad=0.6
+ ckappas=0.6
+ clc=1e-007
+ cle=0.6
+ delta=0.0014285714
+ diomod=1
+ dlc=0
+ dlcig=1.5e-007
+ dmcg=1.5e-007
+ drout=0.56
+ dsub=0.5
+ dvt0=0
+ dvt0w=0
+ dvt1=0.53
+ dvt1w=0
+ dvt2=0
+ dvt2w=0
+ dvtp0=0
+ dvtp1=0
+ dwb=0
+ dwc=0
+ dwg=0
+ ef=0.95
+ egidl=0.8
+ em=4.1e+007
+ epsrox=3.9
+ eta0=0.75
+ etab=-0.32
+ eu=1.67
+ fnoimod=1
+ fprout=0
+ geomod=0
+ igbmod=0
+ igcmod=0
+ ijthsfwd=0.1
+ ijthsrev=0.1
+ jss=2.2959e-007
+ jswgs=0
+ jsws=2.1207e-013
+ k1=0.75941
+ k2=0.016542914
+ k3=0
+ k3b=0
+ keta=-0.043888571
+ kt1=-0.31232714
+ kt1l=0
+ kt2=-0.022392857
+ ku0=0
+ kvsat=0
+ kvth0=0
+ la0=-2.6229429e-007
+ lags=-1.4038286e-007
+ lalpha0=-2.3087143e-012
+ ldelta=4.2857143e-009
+ level=54
+ lint=0
+ lk2=-3.1102457e-008
+ lketa=-1.0255714e-008
+ lkt1=2.9485714e-009
+ lkt2=-4.2857143e-010
+ ll=0
+ lln=1
+ lmax=1.2e-006
+ lmin=5e-007
+ lpclm=6.7911429e-008
+ lpdiblc2=9.06e-010
+ lpe0=1.1e-007
+ lpeb=0
+ ltvoff=0
+ lu0=4.4168571e-009
+ lua=4.2286286e-016
+ lub=-2.1651429e-025
+ lub1=-6.3214286e-025
+ luc1=8.9057143e-018
+ lvoff=-8.2714286e-009
+ lvth0=-1.1202857e-008
+ lw=0
+ lwl=0
+ lwn=1
+ minv=-0.25
+ mjs=0.32071
+ mjswgs=0.32059
+ mjsws=0.1
+ mobmod=0
+ moin=15
+ ndep=3e+017
+ nfactor=1
+ ngate=6e+019
+ njs=1.01
+ noff=2
+ noia='nfet_03v3_noia'
+ noib='nfet_03v3_noib'
+ noic='nfet_03v3_noic'
+ nsd=1e+020
+ ntnoi=1
+ paramchk=1
+ pbs=0.70172
+ pbswgs=0.74743
+ pbsws=0.8062
+ pclm=0.065697143
+ pdiblc1=0.39
+ pdiblc2=0.001359
+ pdiblcb=0.2
+ pdits=0
+ pditsd=0
+ pditsl=0
+ permod=1
+ phin=0.07
+ prt=0
+ prwb=0
+ prwg=0
+ pscbe1=6.6469e+008
+ pscbe2=1.638e-005
+ ptvoff=0
+ pvag=0
+ rbodymod=0
+ rdsmod=0
+ rdsw=530
+ rdswmin=50
+ rdwmin=0
+ rgatemod=0
+ rsh=7
+ rswmin=0
+ saref=4.4e-007
+ sbref=4.4e-007
+ tcj=0.0009438
+ tcjsw=0.00060474
+ tcjswg=0.001
+ tnoimod=0
+ tnom=25
+ toxe=8e-009
+ toxm=8e-009
+ toxp=8e-009
+ toxref=8e-009
+ tpb=0.0018129
+ tpbsw=5e-005
+ tpbswg=0.0016872
+ trnqsmod=0
+ tvoff=0.001
+ u0=0.037617286
+ ua=-9.5796571e-010
+ ua1=1.675e-009
+ ub=3.4056286e-018
+ ub1=-3.0010143e-018
+ uc=1.4868e-010
+ uc1=-1.3899143e-010
+ ute=-1.55
+ vbm=-3
+ version=4.5
+ vfbcv=-1
+ voff=-0.10411714
+ voffcv=0.005
+ voffl=0
+ vsat=85000
+ vth0=0.66297571
+ w0=5e-007
+ wint=1e-008
+ wl=0
+ wln=1
+ wmax=0.000100001
+ wmin=1e-005
+ wr=1
+ wtvoff=0
+ ww=0
+ wwl=0
+ wwn=1
+ xj=1e-007
+ xl=0
+ xpart=0
+ xtis=3
+ xw=0
.model nfet_03v3.14 nmos
+ a0=1.1822018
+ a1=0
+ a2=1
+ acde=0.6
+ acnqsmod=0
+ agidl=1.3268e-010
+ ags=0.26772773
+ alpha0=9.0929986e-005
+ alpha1=0
+ at=23000
+ b0=0
+ b1=0
+ beta0=24.476046
+ bgidl=1.8961e+009
+ binunit=2
+ capmod=2
+ cdsc=0
+ cdscb=0
+ cdscd=0
+ cf=0
+ cgbo=1e-013
+ cgdl=1e-010
+ cgdo=1e-010
+ cgidl=0.5
+ cgsl=1e-010
+ cgso=1e-010
+ cit=0
+ cjs=0.00096797
+ cjswgs=5.9903e-010
+ cjsws=1.5663e-010
+ ckappad=0.6
+ ckappas=0.6
+ clc=1e-007
+ cle=0.6
+ delta=0.0027272727
+ diomod=1
+ dlc=0
+ dlcig=1.5e-007
+ dmcg=1.5e-007
+ drout=0.56
+ dsub=0.5
+ dvt0=0
+ dvt0w=0
+ dvt1=0.53
+ dvt1w=0
+ dvt2=0
+ dvt2w=0
+ dvtp0=0
+ dvtp1=0
+ dwb=0
+ dwc=0
+ dwg=0
+ ef=0.95
+ egidl=0.8
+ em=4.1e+007
+ epsrox=3.9
+ eta0=0.75
+ etab=-0.32
+ eu=1.67
+ fnoimod=1
+ fprout=0
+ geomod=0
+ igbmod=0
+ igcmod=0
+ ijthsfwd=0.1
+ ijthsrev=0.1
+ jss=2.2959e-007
+ jswgs=0
+ jsws=2.1207e-013
+ k1=0.79717136
+ k2=-0.0074231864
+ k3=0
+ k3b=0
+ keta=-0.021025909
+ kt1=-0.31816545
+ kt1l=0
+ kt2=-0.017352273
+ ku0=0
+ kvsat=0
+ kvth0=0
+ la0=-9.2901818e-007
+ lags=2.7852273e-007
+ lalpha0=-1.0337986e-010
+ lbeta0=-4.0704545e-006
+ ldelta=2.7272727e-009
+ level=54
+ lint=0
+ lk1=-4.5313636e-008
+ lk2=-2.3431364e-009
+ lketa=-3.7690909e-008
+ lkt1=9.9545454e-009
+ lkt2=-6.4772727e-009
+ ll=0
+ lln=1
+ lmax=1e-005
+ lmin=1.2e-006
+ lnoff=-1.3636364e-007
+ lpclm=-1.3055455e-007
+ lpdiblc2=1.7686364e-009
+ lpe0=1.1e-007
+ lpeb=0
+ ltvoff=0
+ lu0=1.6854546e-009
+ lua=2.4381818e-016
+ lua1=2.2909091e-017
+ lub=8.1409091e-026
+ lub1=-1.5190909e-024
+ luc=5.52e-017
+ luc1=-1.0305e-016
+ lvoff=1.3159091e-008
+ lvoffcv=7.5e-008
+ lvth0=6.9136364e-009
+ lw=0
+ lwl=0
+ lwn=1
+ minv=-0.25
+ mjs=0.32071
+ mjswgs=0.32059
+ mjsws=0.1
+ mobmod=0
+ moin=15
+ ndep=3e+017
+ nfactor=1
+ ngate=6e+019
+ njs=1.01
+ noff=2.1136364
+ noia='nfet_03v3_noia'
+ noib='nfet_03v3_noib'
+ noic='nfet_03v3_noic'
+ nsd=1e+020
+ ntnoi=1
+ paramchk=1
+ pbs=0.70172
+ pbswgs=0.74743
+ pbsws=0.8062
+ pclm=0.23108545
+ pdiblc1=0.39
+ pdiblc2=0.00064013636
+ pdiblcb=0.2
+ pdits=0
+ pditsd=0
+ pditsl=0
+ permod=1
+ phin=0.07
+ prt=0
+ prwb=0
+ prwg=0
+ pscbe1=6.6469e+008
+ pscbe2=1.638e-005
+ ptvoff=0
+ pvag=0
+ rbodymod=0
+ rdsmod=0
+ rdsw=530
+ rdswmin=50
+ rdwmin=0
+ rgatemod=0
+ rsh=7
+ rswmin=0
+ saref=4.4e-007
+ sbref=4.4e-007
+ tcj=0.0009438
+ tcjsw=0.00060474
+ tcjswg=0.001
+ tnoimod=0
+ tnom=25
+ toxe=8e-009
+ toxm=8e-009
+ toxp=8e-009
+ toxref=8e-009
+ tpb=0.0018129
+ tpbsw=5e-005
+ tpbswg=0.0016872
+ trnqsmod=0
+ tvoff=0.001
+ u0=0.039893455
+ ua=-8.0876182e-010
+ ua1=1.6559091e-009
+ ub=3.1573591e-018
+ ub1=-2.2618909e-018
+ uc=1.0268e-010
+ uc1=-4.5695e-011
+ ute=-1.55
+ vbm=-3
+ version=4.5
+ vfbcv=-1
+ voff=-0.12197591
+ voffcv=-0.0575
+ voffl=0
+ vsat=85000
+ vth0=0.64787864
+ w0=5e-007
+ wint=1e-008
+ wl=0
+ wln=1
+ wmax=0.000100001
+ wmin=1e-005
+ wr=1
+ wtvoff=0
+ ww=0
+ wwl=0
+ wwn=1
+ xj=1e-007
+ xl=0
+ xpart=0
+ xtis=3
+ xw=0
.model nfet_03v3.15 nmos
+ a0=1.0893
+ a1=0
+ a2=1
+ acde=0.6
+ acnqsmod=0
+ agidl=1.3268e-010
+ ags=0.29558
+ alpha0=8.0592e-005
+ alpha1=0
+ at=23000
+ b0=0
+ b1=0
+ beta0=24.069
+ bgidl=1.8961e+009
+ binunit=2
+ capmod=2
+ cdsc=0
+ cdscb=0
+ cdscd=0
+ cf=0
+ cgbo=1e-013
+ cgdl=1e-010
+ cgdo=2.3e-010
+ cgidl=0.5
+ cgsl=1e-010
+ cgso=2.3e-010
+ cit=0
+ cjs=0.00096797
+ cjswgs=5.9903e-010
+ cjsws=1.5663e-010
+ ckappad=0.6
+ ckappas=0.6
+ clc=1e-007
+ cle=0.6
+ delta=0.003
+ diomod=1
+ dlc=3e-008
+ dlcig=1.5e-007
+ dmcg=1.5e-007
+ drout=0.56
+ dsub=0.5
+ dvt0=0
+ dvt0w=0
+ dvt1=0.53
+ dvt1w=0
+ dvt2=0
+ dvt2w=0
+ dvtp0=0
+ dvtp1=0
+ dwb=0
+ dwc=0
+ dwg=0
+ ef=0.95
+ egidl=0.8
+ em=4.1e+007
+ epsrox=3.9
+ eta0=0.75
+ etab=-0.32
+ eu=1.67
+ fnoimod=1
+ fprout=0
+ geomod=0
+ igbmod=0
+ igcmod=0
+ ijthsfwd=0.1
+ ijthsrev=0.1
+ jss=2.2959e-007
+ jswgs=0
+ jsws=2.1207e-013
+ k1=0.79264
+ k2=-0.0076575
+ k3=0
+ k3b=0
+ keta=-0.024795
+ kt1=-0.31717
+ kt1l=0
+ kt2=-0.018
+ ku0=0
+ kvsat=0
+ kvth0=0
+ level=54
+ lint=0
+ ll=0
+ lln=1
+ lmax=5.0001e-005
+ lmin=1e-005
+ lpe0=1.1e-007
+ lpeb=0
+ ltvoff=0
+ lw=0
+ lwl=0
+ lwn=1
+ minv=-0.25
+ mjs=0.32071
+ mjswgs=0.32059
+ mjsws=0.1
+ mobmod=0
+ moin=15
+ ndep=3e+017
+ nfactor=1
+ ngate=6e+019
+ njs=1.01
+ noff=2.1
+ noia='nfet_03v3_noia'
+ noib='nfet_03v3_noib'
+ noic='nfet_03v3_noic'
+ nsd=1e+020
+ ntnoi=1
+ paramchk=1
+ pbs=0.70172
+ pbswgs=0.74743
+ pbsws=0.8062
+ pclm=0.21803
+ pdiblc1=0.39
+ pdiblc2=0.000817
+ pdiblcb=0.2
+ pdits=0
+ pditsd=0
+ pditsl=0
+ permod=1
+ phin=0.07
+ prt=0
+ prwb=0
+ prwg=0
+ pscbe1=6.6469e+008
+ pscbe2=1.638e-005
+ ptvoff=0
+ pvag=0
+ rbodymod=0
+ rdsmod=0
+ rdsw=530
+ rdswmin=50
+ rdwmin=0
+ rgatemod=0
+ rsh=7
+ rswmin=0
+ saref=4.4e-007
+ sbref=4.4e-007
+ tcj=0.0009438
+ tcjsw=0.00060474
+ tcjswg=0.001
+ tnoimod=0
+ tnom=25
+ toxe=8e-009
+ toxm=8e-009
+ toxp=8e-009
+ toxref=8e-009
+ tpb=0.0018129
+ tpbsw=5e-005
+ tpbswg=0.0016872
+ trnqsmod=0
+ tvoff=0.001
+ u0=0.040062
+ ua=-7.8438e-010
+ ua1=1.6582e-009
+ ub=3.1655e-018
+ ub1=-2.4138e-018
+ uc=1.082e-010
+ uc1=-5.6e-011
+ ute=-1.55
+ vbm=-3
+ version=4.5
+ vfbcv=-1
+ voff=-0.12066
+ voffcv=-0.05
+ voffl=0
+ vsat=85000
+ vth0=0.64857
+ w0=5e-007
+ wint=1e-008
+ wl=0
+ wln=1
+ wmax=0.000100001
+ wmin=1e-005
+ wr=1
+ wtvoff=0
+ ww=0
+ wwl=0
+ wwn=1
+ xj=1e-007
+ xl=0
+ xpart=0
+ xtis=3
+ xw=0
.subckt nplus_u_m1 1 2 3 lr=lr wr=wr dtemp=0 r_rsh0=rsh_nplus_u_m r_dw=-5e-8 r_dl=0 r_vc1=0 r_vc2=0 r_tc1=1.36e-3 r_tc2=6.5e-7 r_tnom=25 r_l='lr-2*r_dl' r_w='wr-2*r_dw' r_n='r_l/r_w' r_temp='1+r_tc1*(temper+dtemp-r_tnom)+r_tc2*(temper+dtemp-r_tnom)*(temper+dtemp-r_tnom)'
.model np_junction d
+ cj=0.00096797
+ cjsw=1.5663e-010
+ cta=0.0009438
+ ctp=0.00060474
+ level=3
+ mj=0.32071
+ mjsw=0.1
+ pb=0.70172
+ php=0.8062
+ tlevc=1
+ tpb=0.0018129
+ tphp=5e-005
+ tref=25
d1 3 1 np_junction area='r_w*r_l' pj='2*(r_w+r_l)'
rb 1 2 r='r_temp*r_n*(r_rsh0+r_vc1*abs(v(1,2))/r_n+r_vc2*abs(v(1,2))*abs(v(1,2))/r_n/r_n)'
.ends nplus_u_m1
.subckt pfet_03v3_dss d g s b w=10u l=0.28u nf=1 m=1 par=1 s_sab=0.48u d_sab=1.78u as=0 ad=0 ps=0 pd=0 nrd=0 nrs=0 dtemp=0 sa=0 sb=0 sd=0
.param par_vth=0.00666
.param par_k=0.002833
.param par_l=1.5e-7
.param par_w=-1e-7
.param par_leff='l-par_l'
.param par_weff='par*(w-par_w)'
.param p_sqrtarea='sqrt((par_leff)*(par_weff))'
.param var_k='0.7071*par_k*1e-06/p_sqrtarea'
.param mis_k='agauss(0,var_k,1)'
.param var_vth='0.7071*par_vth*1e-06/p_sqrtarea'
.param mis_vth='agauss(0,var_vth,1)'
xr1 d d1 b pplus_u_m1 wr='w' lr='(d_sab==0)?1e-15:d_sab'
xr2 s s1 b pplus_u_m1 wr='w' lr='(s_sab==0)?1e-15:s_sab'
m0 d1 g s1 b pfet_03v3 ad=ad as=as delvto='mis_vth*sw_stat_mismatch' l='l' m=m mulu0='1-mis_k*sw_stat_mismatch' nf=nf nrd=nrd nrs=nrs pd=pd ps=ps sa=sa sb=sb sd=sd w='w'
.ends
.model pfet_03v3.0 pmos
+ a0=1.0272635
+ a1=0
+ a2=0.99
+ acde=1
+ acnqsmod=0
+ agidl=1.5908e-011
+ ags=0.19081247
+ alpha0=1.1485698e-005
+ alpha1=0
+ at=12000
+ b0=0
+ b1=0
+ beta0=39.773597
+ bgidl=1.3902e+009
+ binunit=2
+ capmod=2
+ cdsc=0.00024
+ cdscb=0
+ cdscd=0
+ cf=0
+ cgbo=1e-013
+ cgdl=4e-011
+ cgdo=1.24e-010
+ cgidl=7.5
+ cgsl=4e-011
+ cgso=1.24e-010
+ cit=0
+ cjs=0.00094344
+ cjswgs=4.794e-010
+ cjsws=1.5078e-010
+ ckappad=0.6
+ ckappas=0.6
+ clc=1e-007
+ cle=0.6
+ delta=0.01
+ diomod=1
+ dlc=-8e-009
+ dlcig=1.5e-007
+ dmcg=1.5e-007
+ drout=0.56
+ dsub=0.3659
+ dvt0=2.8985
+ dvt0w=0
+ dvt1=0.23999
+ dvt1w=5300000
+ dvt2=-0.016
+ dvt2w=-0.032
+ dvtp0=0
+ dvtp1=0
+ dwb=0
+ dwc=0
+ dwg=0
+ ef=1.12
+ egidl=0.1009
+ em=4.1e+007
+ epsrox=3.9
+ eta0=0.2541
+ etab=-0.15284
+ eu=1.67
+ fnoimod=1
+ fprout=0
+ geomod=0
+ igbmod=0
+ igcmod=0
+ ijthsfwd=0.1
+ ijthsrev=0.1
+ jss=1.653e-007
+ jswgs=0
+ jsws=2.1207e-013
+ jtss=1e-011
+ jtsswgs=1e-011
+ jtssws=1e-011
+ k1=0.86959286
+ k2=0.029351195
+ k3=0
+ k3b=0
+ keta=-0.066404636
+ kt1=-0.28373805
+ kt1l=0
+ kt2=-0.013066
+ ku0=0
+ kvsat=0
+ kvth0=0
+ la0=-2.0434818e-007
+ lags=1.0492091e-007
+ lalpha0=-3.0054064e-012
+ lbeta0=-3.6237273e-006
+ level=54
+ lint=0
+ lk1=4.91e-009
+ lk2=-2.4890454e-008
+ lketa=8.2658182e-009
+ lkt1=-1.5974545e-008
+ ll=0
+ lln=1
+ lmax=5e-007
+ lmin=2.8e-007
+ lpclm=7.0823636e-008
+ lpe0=3.2493e-008
+ lpeb=0
+ ltvoff=0
+ lu0=2.4492727e-009
+ lua=1.0386891e-015
+ lua1=1.7181818e-016
+ lub=-1.4361909e-025
+ lub1=-6.7359091e-025
+ luc=8.4861818e-018
+ luc1=5.8570909e-017
+ lvoff=-1.6014546e-009
+ lvth0=-7.6827273e-009
+ lw=0
+ lwl=0
+ lwn=1
+ minv=-0.1
+ mjs=0.32084
+ mjswgs=0.21964
+ mjsws=0.05
+ mobmod=0
+ moin=15
+ ndep=5.6e+017
+ nfactor=0.8
+ ngate=6e+019
+ njs=1
+ njts=20
+ njtssw=20
+ njtsswg=20
+ noff=2.4
+ noia='pfet_03v3_noia'
+ noib='pfet_03v3_noib'
+ noic='pfet_03v3_noic'
+ nsd=1e+020
+ ntnoi=1
+ pa0=-2.7370909e-015
+ pags=-1.2080073e-014
+ palpha0=6.39288e-020
+ paramchk=1
+ pbeta0=1.1827636e-013
+ pbs=0.69939
+ pbswgs=0.65
+ pbsws=0.8022
+ pclm=0.35627558
+ pdiblc1=0.1484
+ pdiblc2=0.00073695
+ pdiblcb=0
+ pdits=0
+ pditsd=0
+ pditsl=0
+ permod=1
+ phin=0
+ pk1=-2.0974909e-014
+ pk2=3.4158327e-015
+ pketa=3.6614618e-015
+ pkt1=1.9400727e-015
+ ppclm=6.5406545e-015
+ prt=0
+ prwb=0
+ prwg=0
+ pscbe1=6.7448e+008
+ pscbe2=1e-005
+ ptvoff=0
+ pu0=-5.2642909e-016
+ pua=-1.9180342e-022
+ pua1=-8.9345454e-023
+ pub=1.3557818e-033
+ pub1=1.4950473e-031
+ puc=-4.4743636e-024
+ puc1=-1.4057018e-023
+ pvag=0
+ pvoff=8.3275636e-016
+ pvth0=2.3570182e-015
+ rbodymod=0
+ rdsmod=0
+ rdsw=466
+ rdswmin=20
+ rgatemod=0
+ rsh=7
+ saref=4.4e-007
+ sbref=4.4e-007
+ tcj=0.00099187
+ tcjsw=0.00063483
+ tcjswg=0.000932
+ tnoimod=0
+ tnom=25
+ toxe=7.9e-009
+ toxm=7.9e-009
+ toxp=7.9e-009
+ toxref=7.9e-009
+ tpb=0.0016906
+ tpbsw=0.0052
+ tpbswg=0.000744
+ trnqsmod=0
+ tvoff=0.0032
+ u0=0.0077071688
+ ua=-2.4381818e-012
+ ua1=1.1563636e-009
+ ub=6.7035533e-019
+ ub1=-2.100161e-018
+ uc=8.6801065e-011
+ uc1=-2.5418182e-010
+ ute=-1
+ vbm=-3
+ version=4.5
+ vfb=0
+ vfbcv=-1
+ voff=-0.094658091
+ voffcv=-0.16
+ voffl=0
+ vsat=94000
+ vth0=-0.7506174
+ vtss=10
+ vtsswgs=10
+ vtssws=10
+ w0=2.5e-006
+ wa0=1.1112467e-008
+ wags=-2.3219283e-008
+ walpha0=-1.0325417e-013
+ wbeta0=2.1005299e-007
+ wint=-1e-008
+ wk1=6.7137132e-008
+ wk2=-2.1522854e-008
+ wketa=-7.3229236e-009
+ wkt1=-1.1172031e-008
+ wl=0
+ wln=1
+ wmax=5e-007
+ wmin=2.2e-007
+ wpclm=2.9266005e-008
+ wtvoff=0
+ wu0=6.0892675e-010
+ wua=3.3100364e-018
+ wua1=1.7869091e-016
+ wub=-4.8420779e-027
+ wub1=-1.4002317e-025
+ wuc=-1.3364176e-017
+ wuc1=4.0843636e-017
+ wvoff=-1.6655127e-009
+ wvth0=4.2938493e-009
+ ww=0
+ wwl=0
+ wwn=1
+ xj=1e-007
+ xl=0
+ xpart=0
+ xtis=3
+ xw=0
.model pfet_03v3.1 pmos
+ a0=1.1510659
+ a1=0
+ a2=0.99
+ acde=1
+ acnqsmod=0
+ agidl=1.5908e-011
+ ags=0.19022326
+ alpha0=7.5504633e-005
+ alpha1=0
+ at=12000
+ b0=0
+ b1=0
+ beta0=42.422959
+ bgidl=1.3902e+009
+ binunit=2
+ capmod=2
+ cdsc=0.00024
+ cdscb=0
+ cdscd=0
+ cf=0
+ cgbo=1e-013
+ cgdl=4e-011
+ cgdo=1.24e-010
+ cgidl=7.5
+ cgsl=4e-011
+ cgso=1.24e-010
+ cit=0
+ cjs=0.00094344
+ cjswgs=4.794e-010
+ cjsws=1.5078e-010
+ ckappad=0.6
+ ckappas=0.6
+ clc=1e-007
+ cle=0.6
+ delta=0.01
+ diomod=1
+ dlc=-8e-009
+ dlcig=1.5e-007
+ dmcg=1.5e-007
+ drout=0.56
+ dsub=0.3659
+ dvt0=2.8985
+ dvt0w=0
+ dvt1=0.23999
+ dvt1w=5300000
+ dvt2=-0.016
+ dvt2w=-0.032
+ dvtp0=0
+ dvtp1=0
+ dwb=0
+ dwc=0
+ dwg=0
+ ef=1.12
+ egidl=0.1009
+ em=4.1e+007
+ epsrox=3.9
+ eta0=0.2541
+ etab=-0.15284
+ eu=1.67
+ fnoimod=1
+ fprout=0
+ geomod=0
+ igbmod=0
+ igcmod=0
+ ijthsfwd=0.1
+ ijthsrev=0.1
+ jss=1.653e-007
+ jswgs=0
+ jsws=2.1207e-013
+ jtss=1e-011
+ jtsswgs=1e-011
+ jtssws=1e-011
+ k1=1.011648
+ k2=-0.018784
+ k3=0
+ k3b=0
+ keta=-0.0050909592
+ kt1=-0.30703735
+ kt1l=0
+ kt2=-0.013066
+ ku0=0
+ kvsat=0
+ kvth0=0
+ la0=-2.6624939e-007
+ lags=1.0521551e-007
+ lalpha0=-3.5014873e-011
+ lbeta0=-4.9484082e-006
+ level=54
+ lint=0
+ lk1=-6.6117551e-008
+ lk2=-8.2285714e-010
+ lketa=-2.239102e-008
+ lkt1=-4.324898e-009
+ ll=0
+ lln=1
+ lmax=1.2e-006
+ lmin=5e-007
+ lpclm=1.2067592e-007
+ lpdiblc2=2.4533143e-010
+ lpe0=3.2493e-008
+ lpeb=0
+ ltvoff=0
+ lu0=1.1587837e-009
+ lua=8.5199265e-016
+ lub=-3.5234082e-025
+ lub1=-6.0410204e-025
+ luc=5.8519641e-017
+ luc1=-3.0738122e-017
+ lvoff=1.2890571e-008
+ lvth0=8.0902041e-009
+ lw=0
+ lwl=0
+ lwn=1
+ minv=-0.1
+ mjs=0.32084
+ mjswgs=0.21964
+ mjsws=0.05
+ mobmod=0
+ moin=15
+ ndep=5.6e+017
+ nfactor=0.8
+ ngate=6e+019
+ njs=1
+ njts=20
+ njtssw=20
+ njtsswg=20
+ noff=2.4
+ noia='pfet_03v3_noia'
+ noib='pfet_03v3_noib'
+ noic='pfet_03v3_noic'
+ nsd=1e+020
+ ntnoi=1
+ pa0=-1.6645518e-014
+ pags=-3.0616751e-014
+ palpha0=-2.3899709e-018
+ paramchk=1
+ pbeta0=8.5195102e-014
+ pbs=0.69939
+ pbswgs=0.65
+ pbsws=0.8022
+ pclm=0.25657102
+ pdiblc1=0.1484
+ pdiblc2=0.00024628714
+ pdiblcb=0
+ pdits=0
+ pditsd=0
+ pditsl=0
+ permod=1
+ phin=0
+ pk1=2.1589126e-014
+ pk2=-6.084e-015
+ pketa=1.1021878e-015
+ pkt1=-1.6167967e-014
+ ppclm=-2.1505078e-014
+ prt=0
+ prwb=0
+ prwg=0
+ pscbe1=6.7448e+008
+ pscbe2=1e-005
+ ptvoff=0
+ pu0=-9.8910367e-017
+ pua=-1.6858315e-022
+ pub=9.5112882e-032
+ pub1=9.6045061e-032
+ puc=-7.4630909e-024
+ puc1=3.2542237e-024
+ pvag=0
+ pvth0=1.5205225e-015
+ rbodymod=0
+ rdsmod=0
+ rdsw=466
+ rdswmin=20
+ rgatemod=0
+ rsh=7
+ saref=4.4e-007
+ sbref=4.4e-007
+ tcj=0.00099187
+ tcjsw=0.00063483
+ tcjswg=0.000932
+ tnoimod=0
+ tnom=25
+ toxe=7.9e-009
+ toxm=7.9e-009
+ toxp=7.9e-009
+ toxref=7.9e-009
+ tpb=0.0016906
+ tpbsw=0.0052
+ tpbswg=0.000744
+ trnqsmod=0
+ tvoff=0.0032
+ u0=0.010288147
+ ua=3.7095469e-010
+ ua1=1.5e-009
+ ub=1.0877988e-018
+ ub1=-2.2391388e-018
+ uc=-1.3265853e-011
+ uc1=-7.5563755e-011
+ ute=-1
+ vbm=-3
+ version=4.5
+ vfb=0
+ vfbcv=-1
+ voff=-0.12364214
+ voffcv=-0.16
+ voffl=0
+ vsat=94000
+ vth0=-0.78216327
+ vtss=10
+ vtsswgs=10
+ vtssws=10
+ w0=2.5e-006
+ wa0=3.8929322e-008
+ wags=1.3854074e-008
+ walpha0=4.8045453e-012
+ wbeta0=2.7621551e-007
+ wint=-1e-008
+ wk1=-1.7990939e-008
+ wk2=-2.5231886e-009
+ wketa=-2.2043755e-009
+ wkt1=2.5044049e-008
+ wl=0
+ wln=1
+ wmax=5e-007
+ wmin=2.2e-007
+ wpclm=8.5357469e-008
+ wtvoff=0
+ wu0=-2.4611069e-010
+ wua=-4.3130498e-017
+ wub=-1.9235628e-025
+ wub1=-3.3103837e-026
+ wuc=-7.386721e-018
+ wuc1=6.2211526e-018
+ wvth0=5.9668408e-009
+ ww=0
+ wwl=0
+ wwn=1
+ xj=1e-007
+ xl=0
+ xpart=0
+ xtis=3
+ xw=0
.model pfet_03v3.2 pmos
+ a0=1.2626103
+ a1=0
+ a2=0.99
+ acde=1
+ acnqsmod=0
+ agidl=1.5908e-011
+ ags=0.15731682
+ alpha0=0.0020588939
+ alpha1=0
+ at=12000
+ b0=0
+ b1=0
+ beta0=44.45026
+ bgidl=1.3902e+009
+ binunit=2
+ capmod=2
+ cdsc=0.00024
+ cdscb=0
+ cdscd=0
+ cf=0
+ cgbo=1e-013
+ cgdl=4e-011
+ cgdo=1.24e-010
+ cgidl=7.5
+ cgsl=4e-011
+ cgso=1.24e-010
+ cit=0
+ cjs=0.00094344
+ cjswgs=4.794e-010
+ cjsws=1.5078e-010
+ ckappad=0.6
+ ckappas=0.6
+ clc=1e-007
+ cle=0.6
+ delta=0.01
+ diomod=1
+ dlc=-8e-009
+ dlcig=1.5e-007
+ dmcg=1.5e-007
+ drout=0.56
+ dsub=0.3659
+ dvt0=2.8985
+ dvt0w=0
+ dvt1=0.23999
+ dvt1w=5300000
+ dvt2=-0.016
+ dvt2w=-0.032
+ dvtp0=0
+ dvtp1=0
+ dwb=0
+ dwc=0
+ dwg=0
+ ef=1.12
+ egidl=0.1009
+ em=4.1e+007
+ epsrox=3.9
+ eta0=0.2541
+ etab=-0.15284
+ eu=1.67
+ fnoimod=1
+ fprout=0
+ geomod=0
+ igbmod=0
+ igcmod=0
+ ijthsfwd=0.1
+ ijthsrev=0.1
+ jss=1.653e-007
+ jswgs=0
+ jsws=2.1207e-013
+ jtss=1e-011
+ jtsswgs=1e-011
+ jtssws=1e-011
+ k1=0.95493474
+ k2=-0.010993416
+ k3=0
+ k3b=0
+ keta=-0.00016272403
+ kt1=-0.26850506
+ kt1l=0
+ kt2=-0.013066
+ ku0=0
+ kvsat=0
+ kvth0=0
+ la0=-4.001026e-007
+ lags=1.4470325e-007
+ lalpha0=-2.415082e-009
+ lbeta0=-7.3811688e-006
+ level=54
+ lint=0
+ lk1=1.9383117e-009
+ lk2=-1.0171558e-008
+ lketa=-2.8304903e-008
+ lkt1=-5.0563636e-008
+ ll=0
+ lln=1
+ lmax=1e-005
+ lmin=1.2e-006
+ lnoff=5.4545454e-007
+ lpclm=4.2841558e-008
+ lpdiblc2=4.4675455e-010
+ lpe0=3.2493e-008
+ lpeb=0
+ ltvoff=0
+ lu0=3.0025909e-009
+ lua=8.1926494e-016
+ lub=-6.9161688e-026
+ lub1=3.3323377e-025
+ luc=9.5515247e-017
+ luc1=-7.8734805e-017
+ lvoff=-1.8220325e-008
+ lvoffcv=-2.1818182e-007
+ lvth0=-9.5551948e-009
+ lw=0
+ lwl=0
+ lwn=1
+ minv=-0.1
+ mjs=0.32084
+ mjswgs=0.21964
+ mjsws=0.05
+ mobmod=0
+ moin=15
+ ndep=5.6e+017
+ nfactor=0.8
+ ngate=6e+019
+ njs=1
+ njts=20
+ njtssw=20
+ njtsswg=20
+ noff=1.9454546
+ noia='pfet_03v3_noia'
+ noib='pfet_03v3_noib'
+ noic='pfet_03v3_noic'
+ nsd=1e+020
+ ntnoi=1
+ pa0=3.4170078e-014
+ pags=-1.4866597e-014
+ palpha0=-2.3332535e-017
+ paramchk=1
+ pbeta0=-6.7464935e-014
+ pbs=0.69939
+ pbswgs=0.65
+ pbsws=0.8022
+ pclm=0.32143299
+ pdiblc1=0.1484
+ pdiblc2=7.8434545e-005
+ pdiblcb=0
+ pdits=0
+ pditsd=0
+ pditsl=0
+ permod=1
+ phin=0
+ pk1=-3.6710649e-014
+ pk2=8.9552104e-015
+ pketa=2.6125948e-015
+ pkt1=2.6293091e-014
+ ppclm=7.4952935e-014
+ prt=0
+ prwb=0
+ prwg=0
+ pscbe1=6.7448e+008
+ pscbe2=1e-005
+ ptvoff=0
+ pu0=-6.5690182e-016
+ pua=-1.5714468e-022
+ pub=-4.1208312e-033
+ pub1=-1.7328156e-031
+ puc=-1.8553586e-023
+ puc1=2.5455553e-023
+ pvag=0
+ pvoff=-1.1894494e-015
+ pvth0=4.2667013e-015
+ rbodymod=0
+ rdsmod=0
+ rdsw=466
+ rdswmin=20
+ rgatemod=0
+ rsh=7
+ saref=4.4e-007
+ sbref=4.4e-007
+ tcj=0.00099187
+ tcjsw=0.00063483
+ tcjswg=0.000932
+ tnoimod=0
+ tnom=25
+ toxe=7.9e-009
+ toxm=7.9e-009
+ toxp=7.9e-009
+ toxref=7.9e-009
+ tpb=0.0016906
+ tpbsw=0.0052
+ tpbswg=0.000744
+ trnqsmod=0
+ tvoff=0.0032
+ u0=0.0087516409
+ ua=3.9822779e-010
+ ua1=1.5e-009
+ ub=8.5181617e-019
+ ub1=-3.0202519e-018
+ uc=-4.4095525e-011
+ uc1=-3.5566519e-011
+ ute=-1
+ vbm=-3
+ version=4.5
+ vfb=0
+ vfbcv=-1
+ voff=-0.097716396
+ voffcv=0.021818182
+ voffl=0
+ vsat=94000
+ vth0=-0.76745877
+ vtss=10
+ vtsswgs=10
+ vtssws=10
+ w0=2.5e-006
+ wa0=-3.4170078e-009
+ wags=7.2894545e-010
+ walpha0=2.2256682e-011
+ wbeta0=4.0343221e-007
+ wint=-1e-008
+ wk1=3.0592208e-008
+ wk2=-1.5055864e-008
+ wketa=-3.463048e-009
+ wkt1=-1.0340166e-008
+ wl=0
+ wln=1
+ wmax=5e-007
+ wmin=2.2e-007
+ wpclm=4.9757922e-009
+ wtvoff=0
+ wu0=2.1888218e-010
+ wua=-5.2662561e-017
+ wub=-1.0966152e-025
+ wub1=1.9133501e-025
+ wuc=1.8553586e-018
+ wuc1=-1.2279955e-017
+ wvoff=9.9120779e-010
+ wvth0=3.6783584e-009
+ ww=0
+ wwl=0
+ wwn=1
+ xj=1e-007
+ xl=0
+ xpart=0
+ xtis=3
+ xw=0
.model pfet_03v3.3 pmos
+ a0=1.2226
+ a1=0
+ a2=0.99
+ acde=1
+ acnqsmod=0
+ agidl=1.5908e-011
+ ags=0.17178714
+ alpha0=0.0018173857
+ alpha1=0
+ at=12000
+ b0=0
+ b1=0
+ beta0=43.712143
+ bgidl=1.3902e+009
+ binunit=2
+ capmod=2
+ cdsc=0.00024
+ cdscb=0
+ cdscd=0
+ cf=0
+ cgbo=1e-013
+ cgdl=4e-011
+ cgdo=1.24e-010
+ cgidl=7.5
+ cgsl=4e-011
+ cgso=1.24e-010
+ cit=0
+ cjs=0.00094344
+ cjswgs=4.794e-010
+ cjsws=1.5078e-010
+ ckappad=0.6
+ ckappas=0.6
+ clc=1e-007
+ cle=0.6
+ delta=0.01
+ diomod=1
+ dlc=-8e-009
+ dlcig=1.5e-007
+ dmcg=1.5e-007
+ drout=0.56
+ dsub=0.3659
+ dvt0=2.8985
+ dvt0w=0
+ dvt1=0.23999
+ dvt1w=5300000
+ dvt2=-0.016
+ dvt2w=-0.032
+ dvtp0=0
+ dvtp1=0
+ dwb=0
+ dwc=0
+ dwg=0
+ ef=1.12
+ egidl=0.1009
+ em=4.1e+007
+ epsrox=3.9
+ eta0=0.2541
+ etab=-0.15284
+ eu=1.67
+ fnoimod=1
+ fprout=0
+ geomod=0
+ igbmod=0
+ igcmod=0
+ ijthsfwd=0.1
+ ijthsrev=0.1
+ jss=1.653e-007
+ jswgs=0
+ jsws=2.1207e-013
+ jtss=1e-011
+ jtsswgs=1e-011
+ jtssws=1e-011
+ k1=0.95512857
+ k2=-0.012010571
+ k3=0
+ k3b=0
+ keta=-0.0029932143
+ kt1=-0.27356143
+ kt1l=0
+ kt2=-0.013066
+ ku0=0
+ kvsat=0
+ kvth0=0
+ level=54
+ lint=0
+ ll=0
+ lln=1
+ lmax=5.0001e-005
+ lmin=1e-005
+ lpe0=3.2493e-008
+ lpeb=0
+ ltvoff=0
+ lw=0
+ lwl=0
+ lwn=1
+ minv=-0.1
+ mjs=0.32084
+ mjswgs=0.21964
+ mjsws=0.05
+ mobmod=0
+ moin=15
+ ndep=5.6e+017
+ nfactor=0.8
+ ngate=6e+019
+ njs=1
+ njts=20
+ njtssw=20
+ njtsswg=20
+ noff=2
+ noia='pfet_03v3_noia'
+ noib='pfet_03v3_noib'
+ noic='pfet_03v3_noic'
+ nsd=1e+020
+ ntnoi=1
+ paramchk=1
+ pbs=0.69939
+ pbswgs=0.65
+ pbsws=0.8022
+ pclm=0.32571714
+ pdiblc1=0.1484
+ pdiblc2=0.00012311
+ pdiblcb=0
+ pdits=0
+ pditsd=0
+ pditsl=0
+ permod=1
+ phin=0
+ prt=0
+ prwb=0
+ prwg=0
+ pscbe1=6.7448e+008
+ pscbe2=1e-005
+ ptvoff=0
+ pvag=0
+ rbodymod=0
+ rdsmod=0
+ rdsw=466
+ rdswmin=20
+ rgatemod=0
+ rsh=7
+ saref=4.4e-007
+ sbref=4.4e-007
+ tcj=0.00099187
+ tcjsw=0.00063483
+ tcjswg=0.000932
+ tnoimod=0
+ tnom=25
+ toxe=7.9e-009
+ toxm=7.9e-009
+ toxp=7.9e-009
+ toxref=7.9e-009
+ tpb=0.0016906
+ tpbsw=0.0052
+ tpbswg=0.000744
+ trnqsmod=0
+ tvoff=0.0032
+ u0=0.0090519
+ ua=4.8015429e-010
+ ua1=1.5e-009
+ ub=8.449e-019
+ ub1=-2.9869286e-018
+ uc=-3.4544e-011
+ uc1=-4.344e-011
+ ute=-1
+ vbm=-3
+ version=4.5
+ vfb=0
+ vfbcv=-1
+ voff=-0.099538429
+ voffcv=0
+ voffl=0
+ vsat=94000
+ vth0=-0.76841429
+ vtss=10
+ vtsswgs=10
+ vtssws=10
+ w0=2.5e-006
+ wags=-7.5771429e-010
+ walpha0=1.9923429e-011
+ wbeta0=3.9668571e-007
+ wint=-1e-008
+ wk1=2.6921143e-008
+ wk2=-1.4160343e-008
+ wketa=-3.2017886e-009
+ wkt1=-7.7108571e-009
+ wl=0
+ wln=1
+ wmax=5e-007
+ wmin=2.2e-007
+ wpclm=1.2471086e-008
+ wtvoff=0
+ wu0=1.53192e-010
+ wua=-6.8377029e-017
+ wub=-1.100736e-025
+ wub1=1.7400686e-025
+ wuc1=-9.7344e-018
+ wvoff=8.7226286e-010
+ wvth0=4.1050286e-009
+ ww=0
+ wwl=0
+ wwn=1
+ xj=1e-007
+ xl=0
+ xpart=0
+ xtis=3
+ xw=0
.model pfet_03v3.4 pmos
+ a0=0.66833429
+ a1=0
+ a2=0.99
+ acde=1
+ acnqsmod=0
+ agidl=1.5908e-011
+ ags=0.20459958
+ alpha0=1.2079775e-005
+ alpha1=0
+ at=12000
+ b0=0
+ b1=0
+ beta0=38.238696
+ bgidl=1.3902e+009
+ binunit=2
+ capmod=2
+ cdsc=0.00024
+ cdscb=0
+ cdscd=0
+ cf=0
+ cgbo=1e-013
+ cgdl=4e-011
+ cgdo=1.24e-010
+ cgidl=7.5
+ cgsl=4e-011
+ cgso=1.24e-010
+ cit=0
+ cjs=0.00094344
+ cjswgs=4.794e-010
+ cjsws=1.5078e-010
+ ckappad=0.6
+ ckappas=0.6
+ clc=1e-007
+ cle=0.6
+ delta=0.01
+ diomod=1
+ dlc=-8e-009
+ dlcig=1.5e-007
+ dmcg=1.5e-007
+ drout=0.56
+ dsub=0.3659
+ dvt0=2.8985
+ dvt0w=0
+ dvt1=0.23999
+ dvt1w=5300000
+ dvt2=-0.016
+ dvt2w=-0.032
+ dvtp0=0
+ dvtp1=0
+ dwb=0
+ dwc=0
+ dwg=0
+ ef=1.12
+ egidl=0.1009
+ em=4.1e+007
+ epsrox=3.9
+ eta0=0.2541
+ etab=-0.15284
+ eu=1.67
+ fnoimod=1
+ fprout=0
+ geomod=0
+ igbmod=0
+ igcmod=0
+ ijthsfwd=0.1
+ ijthsrev=0.1
+ jss=1.653e-007
+ jswgs=0
+ jsws=2.1207e-013
+ jtss=1e-011
+ jtsswgs=1e-011
+ jtssws=1e-011
+ k1=0.99870273
+ k2=0.014249873
+ k3=0
+ k3b=0
+ keta=-0.10490303
+ kt1=-0.33225761
+ kt1l=0
+ kt2=-0.013066
+ ku0=0
+ kvsat=0
+ kvth0=0
+ la0=-1.03128e-007
+ lags=6.9689636e-008
+ lalpha0=-3.0255502e-012
+ lbeta0=-2.7152909e-006
+ level=54
+ lint=0
+ lk1=-3.5426364e-008
+ lk2=-2.0467636e-008
+ lketa=2.2143527e-008
+ lkt1=5.3309091e-010
+ ll=0
+ lln=1
+ lmax=5e-007
+ lmin=2.8e-007
+ lpclm=2.7248545e-008
+ lpe0=3.2493e-008
+ lpeb=0
+ ltvoff=0
+ lu0=1.8372909e-009
+ lua=7.4813818e-016
+ lua1=-2.562e-016
+ lub=-3.0903909e-025
+ lub1=-2.9730909e-026
+ luc=1.2453182e-017
+ luc1=-3.4608e-017
+ lvth0=-2.1407273e-009
+ lw=0
+ lwl=0
+ lwn=1
+ minv=-0.1
+ mjs=0.32084
+ mjswgs=0.21964
+ mjsws=0.05
+ mobmod=0
+ moin=15
+ ndep=5.6e+017
+ nfactor=0.8
+ ngate=6e+019
+ njs=1
+ njts=20
+ njtssw=20
+ njtsswg=20
+ noff=2.4
+ noia='pfet_03v3_noia'
+ noib='pfet_03v3_noib'
+ noic='pfet_03v3_noic'
+ nsd=1e+020
+ ntnoi=1
+ pa0=-5.5371585e-014
+ pags=6.2401891e-015
+ palpha0=7.4403585e-020
+ paramchk=1
+ pbeta0=-3.5411055e-013
+ pbs=0.69939
+ pbswgs=0.65
+ pbsws=0.8022
+ pclm=0.3781492
+ pdiblc1=0.1484
+ pdiblc2=0.00073695
+ pdiblcb=0
+ pdits=0
+ pditsd=0
+ pditsl=0
+ permod=1
+ phin=0
+ pk2=1.1159673e-015
+ pketa=-3.5549469e-015
+ pkt1=-6.6438982e-015
+ ppclm=2.9199702e-014
+ prt=0
+ prwb=0
+ prwg=0
+ pscbe1=6.7448e+008
+ pscbe2=1e-005
+ ptvoff=0
+ pu0=-2.0819854e-016
+ pua=-4.0716945e-023
+ pua1=1.33224e-022
+ pub=8.7374182e-032
+ pub1=-1.8530247e-031
+ puc=-6.5372036e-024
+ puc1=3.4396015e-023
+ pvag=0
+ pvth0=-5.2482182e-016
+ rbodymod=0
+ rdsmod=0
+ rdsw=466
+ rdswmin=20
+ rgatemod=0
+ rsh=7
+ saref=4.4e-007
+ sbref=4.4e-007
+ tcj=0.00099187
+ tcjsw=0.00063483
+ tcjswg=0.000932
+ tnoimod=0
+ tnom=25
+ toxe=7.9e-009
+ toxm=7.9e-009
+ toxp=7.9e-009
+ toxref=7.9e-009
+ tpb=0.0016906
+ tpbsw=0.0052
+ tpbswg=0.000744
+ trnqsmod=0
+ tvoff=0.0032
+ u0=0.0091928468
+ ua=-8.0522078e-011
+ ua1=2.0124e-009
+ ub=1.748897e-018
+ ub1=-2.8876353e-018
+ uc=8.6704408e-011
+ uc1=6.432e-012
+ ute=-1
+ vbm=-3
+ version=4.5
+ vfb=0
+ vfbcv=-1
+ voff=-0.097861
+ voffcv=-0.16
+ voffl=0
+ vsat=94000
+ vth0=-0.7710094
+ vtss=10
+ vtsswgs=10
+ vtssws=10
+ w0=2.5e-006
+ wa0=1.9775566e-007
+ wags=-3.0388584e-008
+ walpha0=-4.121738e-013
+ wbeta0=1.0082017e-006
+ wint=-1e-008
+ wk2=-1.3670166e-008
+ wketa=1.2696239e-008
+ wkt1=1.4058139e-008
+ wl=0
+ wln=1
+ wmax=1.2e-006
+ wmin=5e-007
+ wpclm=1.7891728e-008
+ wtvoff=0
+ wu0=-1.6362577e-010
+ wua=4.3913662e-017
+ wua1=-2.66448e-016
+ wub=-5.6568377e-025
+ wub1=2.6946346e-025
+ wuc=-1.3313914e-017
+ wuc1=-9.4675549e-017
+ wvth0=1.4897689e-008
+ ww=0
+ wwl=0
+ wwn=1
+ xj=1e-007
+ xl=0
+ xpart=0
+ xtis=3
+ xw=0
.model pfet_03v3.5 pmos
+ a0=1.3454526
+ a1=0
+ a2=0.99
+ acde=1
+ acnqsmod=0
+ agidl=1.5908e-011
+ ags=0.19226653
+ alpha0=0.000123026
+ alpha1=0
+ at=12000
+ b0=0
+ b1=0
+ beta0=43.366204
+ bgidl=1.3902e+009
+ binunit=2
+ capmod=2
+ cdsc=0.00024
+ cdscb=0
+ cdscd=0
+ cf=0
+ cgbo=1e-013
+ cgdl=4e-011
+ cgdo=1.24e-010
+ cgidl=7.5
+ cgsl=4e-011
+ cgso=1.24e-010
+ cit=0
+ cjs=0.00094344
+ cjswgs=4.794e-010
+ cjsws=1.5078e-010
+ ckappad=0.6
+ ckappas=0.6
+ clc=1e-007
+ cle=0.6
+ delta=0.01
+ diomod=1
+ dlc=-8e-009
+ dlcig=1.5e-007
+ dmcg=1.5e-007
+ drout=0.56
+ dsub=0.3659
+ dvt0=2.8985
+ dvt0w=0
+ dvt1=0.23999
+ dvt1w=5300000
+ dvt2=-0.016
+ dvt2w=-0.032
+ dvtp0=0
+ dvtp1=0
+ dwb=0
+ dwc=0
+ dwg=0
+ ef=1.12
+ egidl=0.1009
+ em=4.1e+007
+ epsrox=3.9
+ eta0=0.2541
+ etab=-0.15284
+ eu=1.67
+ fnoimod=1
+ fprout=0
+ geomod=0
+ igbmod=0
+ igcmod=0
+ ijthsfwd=0.1
+ ijthsrev=0.1
+ jss=1.653e-007
+ jswgs=0
+ jsws=2.1207e-013
+ jtss=1e-011
+ jtsswgs=1e-011
+ jtssws=1e-011
+ k1=0.97705
+ k2=-0.026847376
+ k3=0
+ k3b=0
+ keta=-0.0016565918
+ kt1=-0.28366163
+ kt1l=0
+ kt2=-0.013066
+ ku0=0
+ kvsat=0
+ kvth0=0
+ la0=-4.4168718e-007
+ lags=7.5856163e-008
+ lalpha0=-5.8498663e-011
+ lbeta0=-5.2790449e-006
+ level=54
+ lint=0
+ lk1=-2.46e-008
+ lk2=8.0987755e-011
+ lketa=-2.947969e-008
+ lkt1=-2.3764898e-008
+ ll=0
+ lln=1
+ lmax=1.2e-006
+ lmin=5e-007
+ lpclm=-5.9909388e-008
+ lpdiblc2=2.4533143e-010
+ lpe0=3.2493e-008
+ lpeb=0
+ ltvoff=0
+ lu0=1.5601469e-009
+ lua=5.7398498e-016
+ lub=-7.120898e-026
+ lub1=9.5240816e-026
+ luc=5.1804544e-017
+ luc1=1.8185143e-017
+ lvoff=1.2890571e-008
+ lvth0=-3.242449e-010
+ lw=0
+ lwl=0
+ lwn=1
+ minv=-0.1
+ mjs=0.32084
+ mjswgs=0.21964
+ mjsws=0.05
+ mobmod=0
+ moin=15
+ ndep=5.6e+017
+ nfactor=0.8
+ ngate=6e+019
+ njs=1
+ njts=20
+ njtssw=20
+ njtsswg=20
+ noff=2.4
+ noia='pfet_03v3_noia'
+ noib='pfet_03v3_noib'
+ noic='pfet_03v3_noic'
+ nsd=1e+020
+ ntnoi=1
+ pa0=7.4582136e-014
+ pags=-1.5349891e-014
+ palpha0=9.8215995e-018
+ paramchk=1
+ pbeta0=2.571262e-013
+ pbs=0.69939
+ pbswgs=0.65
+ pbsws=0.8022
+ pclm=0.55246506
+ pdiblc1=0.1484
+ pdiblc2=0.00024628714
+ pdiblcb=0
+ pdits=0
+ pditsd=0
+ pditsl=0
+ permod=1
+ phin=0
+ pk2=-6.5539994e-015
+ pketa=4.7882958e-015
+ pkt1=-6.0591673e-015
+ ppclm=7.2399282e-014
+ prt=0
+ prwb=0
+ prwg=0
+ pscbe1=6.7448e+008
+ pscbe2=1e-005
+ ptvoff=0
+ pu0=-3.0761926e-016
+ pua=-2.4019161e-023
+ pub=-5.1075673e-032
+ pub1=-2.6761322e-031
+ puc=-3.9712404e-024
+ puc1=-2.2185874e-023
+ pvag=0
+ pvth0=5.8960359e-015
+ rbodymod=0
+ rdsmod=0
+ rdsw=466
+ rdswmin=20
+ rgatemod=0
+ rsh=7
+ saref=4.4e-007
+ sbref=4.4e-007
+ tcj=0.00099187
+ tcjsw=0.00063483
+ tcjswg=0.000932
+ tnoimod=0
+ tnom=25
+ toxe=7.9e-009
+ toxm=7.9e-009
+ toxp=7.9e-009
+ toxref=7.9e-009
+ tpb=0.0016906
+ tpbsw=0.0052
+ tpbswg=0.000744
+ trnqsmod=0
+ tvoff=0.0032
+ u0=0.0097471347
+ ua=2.6778433e-010
+ ua1=1.5e-009
+ ub=1.2732368e-018
+ ub1=-3.1375788e-018
+ uc=8.0016841e-012
+ uc1=-9.9154286e-011
+ ute=-1
+ vbm=-3
+ version=4.5
+ vfb=0
+ vfbcv=-1
+ voff=-0.12364214
+ voffcv=-0.16
+ voffl=0
+ vsat=94000
+ vth0=-0.77464237
+ vtss=10
+ vtsswgs=10
+ vtssws=10
+ w0=2.5e-006
+ wa0=-6.215178e-008
+ wags=1.2791576e-008
+ walpha0=-1.9906566e-011
+ wbeta0=-2.1427184e-007
+ wint=-1e-008
+ wk2=1.6697667e-009
+ wketa=-3.9902465e-009
+ wkt1=1.2888678e-008
+ wl=0
+ wln=1
+ wmax=1.2e-006
+ wmin=5e-007
+ wpclm=-6.8507432e-008
+ wtvoff=0
+ wu0=3.5215673e-011
+ wua=1.0518093e-017
+ wub=-2.8878406e-025
+ wub1=4.3408496e-025
+ wuc=-1.844584e-017
+ wuc1=1.8488229e-017
+ wvth0=2.0559739e-009
+ ww=0
+ wwl=0
+ wwn=1
+ xj=1e-007
+ xl=0
+ xpart=0
+ xtis=3
+ xw=0
.model pfet_03v3.6 pmos
+ a0=1.1189871
+ a1=0
+ a2=0.99
+ acde=1
+ acnqsmod=0
+ agidl=1.5908e-011
+ ags=0.16561084
+ alpha0=0.002173683
+ alpha1=0
+ at=12000
+ b0=0
+ b1=0
+ beta0=44.354662
+ bgidl=1.3902e+009
+ binunit=2
+ capmod=2
+ cdsc=0.00024
+ cdscb=0
+ cdscd=0
+ cf=0
+ cgbo=1e-013
+ cgdl=4e-011
+ cgdo=1.24e-010
+ cgidl=7.5
+ cgsl=4e-011
+ cgso=1.24e-010
+ cit=0
+ cjs=0.00094344
+ cjswgs=4.794e-010
+ cjsws=1.5078e-010
+ ckappad=0.6
+ ckappas=0.6
+ clc=1e-007
+ cle=0.6
+ delta=0.01
+ diomod=1
+ dlc=-8e-009
+ dlcig=1.5e-007
+ dmcg=1.5e-007
+ drout=0.56
+ dsub=0.3659
+ dvt0=2.8985
+ dvt0w=0
+ dvt1=0.23999
+ dvt1w=5300000
+ dvt2=-0.016
+ dvt2w=-0.032
+ dvtp0=0
+ dvtp1=0
+ dwb=0
+ dwc=0
+ dwg=0
+ ef=1.12
+ egidl=0.1009
+ em=4.1e+007
+ epsrox=3.9
+ eta0=0.2541
+ etab=-0.15284
+ eu=1.67
+ fnoimod=1
+ fprout=0
+ geomod=0
+ igbmod=0
+ igcmod=0
+ ijthsfwd=0.1
+ ijthsrev=0.1
+ jss=1.653e-007
+ jswgs=0
+ jsws=2.1207e-013
+ jtss=1e-011
+ jtsswgs=1e-011
+ jtssws=1e-011
+ k1=1.0137659
+ k2=-0.027452061
+ k3=0
+ k3b=0
+ keta=-0.0068224318
+ kt1=-0.33774851
+ kt1l=0
+ kt2=-0.016947818
+ ku0=0
+ kvsat=0
+ kvth0=0
+ la0=-1.6992857e-007
+ lags=1.0784299e-007
+ lalpha0=-2.519287e-009
+ lbeta0=-6.4651948e-006
+ level=54
+ lint=0
+ lk1=-6.8659091e-008
+ lk2=8.0661039e-010
+ lketa=-2.3280682e-008
+ lkt1=4.1139351e-008
+ lkt2=4.6581818e-009
+ ll=0
+ lln=1
+ lmax=1e-005
+ lmin=1.2e-006
+ lnoff=5.4545454e-007
+ lpclm=2.0841896e-007
+ lpdiblc2=4.4675455e-010
+ lpe0=3.2493e-008
+ lpeb=0
+ ltvoff=0
+ lu0=1.5779454e-009
+ lua=4.1154156e-016
+ lub=5.7264156e-026
+ lub1=-5.5351558e-025
+ luc=6.0010667e-017
+ luc1=-4.9745455e-017
+ lvoff=-2.0507727e-008
+ lvoffcv=-2.1818182e-007
+ lvth0=-1.3737662e-009
+ lw=0
+ lwl=0
+ lwn=1
+ minv=-0.1
+ mjs=0.32084
+ mjswgs=0.21964
+ mjsws=0.05
+ mobmod=0
+ moin=15
+ ndep=5.6e+017
+ nfactor=0.8
+ ngate=6e+019
+ njs=1
+ njts=20
+ njtssw=20
+ njtsswg=20
+ noff=1.9454546
+ noia='pfet_03v3_noia'
+ noib='pfet_03v3_noib'
+ noic='pfet_03v3_noic'
+ nsd=1e+020
+ ntnoi=1
+ pa0=-8.5520416e-014
+ pags=4.3007377e-015
+ palpha0=3.0854085e-017
+ paramchk=1
+ pbeta0=-5.4377143e-013
+ pbs=0.69939
+ pbswgs=0.65
+ pbsws=0.8022
+ pclm=0.3288581
+ pdiblc1=0.1484
+ pdiblc2=7.8434545e-005
+ pdiblcb=0
+ pdits=0
+ pditsd=0
+ pditsl=0
+ permod=1
+ phin=0
+ pk2=3.2465626e-015
+ pkt1=-2.1392462e-014
+ pkt2=-2.4222546e-015
+ ppclm=-1.1147314e-014
+ prt=0
+ prwb=0
+ prwg=0
+ pscbe1=6.7448e+008
+ pscbe2=1e-005
+ ptvoff=0
+ pu0=8.3913818e-017
+ pua=5.487148e-023
+ pub=-6.986227e-032
+ pub1=2.878281e-031
+ puc=-9.1205299e-026
+ puc1=1.0381091e-023
+ pvag=0
+ pvth0=1.2358442e-017
+ rbodymod=0
+ rdsmod=0
+ rdsw=466
+ rdswmin=20
+ rgatemod=0
+ rsh=7
+ saref=4.4e-007
+ sbref=4.4e-007
+ tcj=0.00099187
+ tcjsw=0.00063483
+ tcjswg=0.000932
+ tnoimod=0
+ tnom=25
+ toxe=7.9e-009
+ toxm=7.9e-009
+ toxp=7.9e-009
+ toxref=7.9e-009
+ tpb=0.0016906
+ tpbsw=0.0052
+ tpbswg=0.000744
+ trnqsmod=0
+ tvoff=0.0032
+ u0=0.0097323026
+ ua=4.0315384e-010
+ ua1=1.5e-009
+ ub=1.1661759e-018
+ ub1=-2.5969484e-018
+ uc=1.1632475e-012
+ uc1=-4.2545455e-011
+ ute=-1
+ vbm=-3
+ version=4.5
+ vfb=0
+ vfbcv=-1
+ voff=-0.095810227
+ voffcv=0.021818182
+ voffl=0
+ vsat=94000
+ vth0=-0.77376777
+ vtss=10
+ vtsswgs=10
+ vtssws=10
+ w0=2.5e-006
+ wa0=7.1267013e-008
+ wags=-3.583948e-009
+ walpha0=-3.7433637e-011
+ wbeta0=4.5314286e-007
+ wint=-1e-008
+ wk2=-6.4973683e-009
+ wkt1=2.5666423e-008
+ wkt2=2.0185455e-009
+ wl=0
+ wln=1
+ wmax=1.2e-006
+ wmin=5e-007
+ wpclm=1.1147314e-009
+ wtvoff=0
+ wu0=-2.910619e-010
+ wua=-5.5224108e-017
+ wub=-2.7312856e-025
+ wub1=-2.878281e-026
+ wuc=-2.1679203e-017
+ wuc1=-8.6509091e-018
+ wvth0=6.9590384e-009
+ ww=0
+ wwl=0
+ wwn=1
+ xj=1e-007
+ xl=0
+ xpart=0
+ xtis=3
+ xw=0
.model pfet_03v3.7 pmos
+ a0=1.1019943
+ a1=0
+ a2=0.99
+ acde=1
+ acnqsmod=0
+ agidl=1.5908e-011
+ ags=0.17639514
+ alpha0=0.0019217543
+ alpha1=0
+ at=12000
+ b0=0
+ b1=0
+ beta0=43.708143
+ bgidl=1.3902e+009
+ binunit=2
+ capmod=2
+ cdsc=0.00024
+ cdscb=0
+ cdscd=0
+ cf=0
+ cgbo=1e-013
+ cgdl=4e-011
+ cgdo=1.24e-010
+ cgidl=7.5
+ cgsl=4e-011
+ cgso=1.24e-010
+ cit=0
+ cjs=0.00094344
+ cjswgs=4.794e-010
+ cjsws=1.5078e-010
+ ckappad=0.6
+ ckappas=0.6
+ clc=1e-007
+ cle=0.6
+ delta=0.01
+ diomod=1
+ dlc=-8e-009
+ dlcig=1.5e-007
+ dmcg=1.5e-007
+ drout=0.56
+ dsub=0.3659
+ dvt0=2.8985
+ dvt0w=0
+ dvt1=0.23999
+ dvt1w=5300000
+ dvt2=-0.016
+ dvt2w=-0.032
+ dvtp0=0
+ dvtp1=0
+ dwb=0
+ dwc=0
+ dwg=0
+ ef=1.12
+ egidl=0.1009
+ em=4.1e+007
+ epsrox=3.9
+ eta0=0.2541
+ etab=-0.15284
+ eu=1.67
+ fnoimod=1
+ fprout=0
+ geomod=0
+ igbmod=0
+ igcmod=0
+ ijthsfwd=0.1
+ ijthsrev=0.1
+ jss=1.653e-007
+ jswgs=0
+ jsws=2.1207e-013
+ jtss=1e-011
+ jtsswgs=1e-011
+ jtssws=1e-011
+ k1=1.0069
+ k2=-0.0273714
+ k3=0
+ k3b=0
+ keta=-0.0091505
+ kt1=-0.33363457
+ kt1l=0
+ kt2=-0.016482
+ ku0=0
+ kvsat=0
+ kvth0=0
+ level=54
+ lint=0
+ ll=0
+ lln=1
+ lmax=5.0001e-005
+ lmin=1e-005
+ lpe0=3.2493e-008
+ lpeb=0
+ ltvoff=0
+ lw=0
+ lwl=0
+ lwn=1
+ minv=-0.1
+ mjs=0.32084
+ mjswgs=0.21964
+ mjsws=0.05
+ mobmod=0
+ moin=15
+ ndep=5.6e+017
+ nfactor=0.8
+ ngate=6e+019
+ njs=1
+ njts=20
+ njtssw=20
+ njtsswg=20
+ noff=2
+ noia='pfet_03v3_noia'
+ noib='pfet_03v3_noib'
+ noic='pfet_03v3_noic'
+ nsd=1e+020
+ ntnoi=1
+ paramchk=1
+ pbs=0.69939
+ pbswgs=0.65
+ pbsws=0.8022
+ pclm=0.3497
+ pdiblc1=0.1484
+ pdiblc2=0.00012311
+ pdiblcb=0
+ pdits=0
+ pditsd=0
+ pditsl=0
+ permod=1
+ phin=0
+ prt=0
+ prwb=0
+ prwg=0
+ pscbe1=6.7448e+008
+ pscbe2=1e-005
+ ptvoff=0
+ pvag=0
+ rbodymod=0
+ rdsmod=0
+ rdsw=466
+ rdswmin=20
+ rgatemod=0
+ rsh=7
+ saref=4.4e-007
+ sbref=4.4e-007
+ tcj=0.00099187
+ tcjsw=0.00063483
+ tcjswg=0.000932
+ tnoimod=0
+ tnom=25
+ toxe=7.9e-009
+ toxm=7.9e-009
+ toxp=7.9e-009
+ toxref=7.9e-009
+ tpb=0.0016906
+ tpbsw=0.0052
+ tpbswg=0.000744
+ trnqsmod=0
+ tvoff=0.0032
+ u0=0.0098900971
+ ua=4.44308e-010
+ ua1=1.5e-009
+ ub=1.1719023e-018
+ ub1=-2.6523e-018
+ uc=7.1643143e-012
+ uc1=-4.752e-011
+ ute=-1
+ vbm=-3
+ version=4.5
+ vfb=0
+ vfbcv=-1
+ voff=-0.097861
+ voffcv=0
+ voffl=0
+ vsat=94000
+ vth0=-0.77390514
+ vtss=10
+ vtsswgs=10
+ vtssws=10
+ w0=2.5e-006
+ wa0=6.2714971e-008
+ wags=-3.1538743e-009
+ walpha0=-3.4348229e-011
+ wbeta0=3.9876571e-007
+ wint=-1e-008
+ wk2=-6.172712e-009
+ wkt1=2.3527177e-008
+ wkt2=1.77632e-009
+ wl=0
+ wln=1
+ wmax=1.2e-006
+ wmin=5e-007
+ wtvoff=0
+ wu0=-2.8267051e-010
+ wua=-4.973696e-017
+ wub=-2.8011479e-025
+ wuc=-2.1688323e-017
+ wuc1=-7.6128e-018
+ wvth0=6.9602743e-009
+ ww=0
+ wwl=0
+ wwn=1
+ xj=1e-007
+ xl=0
+ xpart=0
+ xtis=3
+ xw=0
.model pfet_03v3.8 pmos
+ a0=0.8879706
+ a1=0
+ a2=0.99
+ acde=1
+ acnqsmod=0
+ agidl=1.5908e-011
+ ags=0.3341873
+ alpha0=9.723125e-006
+ alpha1=0
+ at=12000
+ b0=0
+ b1=0
+ beta0=37.805966
+ bgidl=1.3902e+009
+ binunit=2
+ capmod=2
+ cdsc=0.00024
+ cdscb=0
+ cdscd=0
+ cf=0
+ cgbo=1e-013
+ cgdl=4e-011
+ cgdo=1.24e-010
+ cgidl=7.5
+ cgsl=4e-011
+ cgso=1.24e-010
+ cit=0
+ cjs=0.00094344
+ cjswgs=4.794e-010
+ cjsws=1.5078e-010
+ ckappad=0.6
+ ckappas=0.6
+ clc=1e-007
+ cle=0.6
+ delta=0.01
+ diomod=1
+ dlc=-8e-009
+ dlcig=1.5e-007
+ dmcg=1.5e-007
+ drout=0.56
+ dsub=0.3659
+ dvt0=2.8985
+ dvt0w=0
+ dvt1=0.23999
+ dvt1w=5300000
+ dvt2=-0.016
+ dvt2w=-0.032
+ dvtp0=0
+ dvtp1=0
+ dwb=0
+ dwc=0
+ dwg=0
+ ef=1.12
+ egidl=0.1009
+ em=4.1e+007
+ epsrox=3.9
+ eta0=0.2541
+ etab=-0.15284
+ eu=1.67
+ fnoimod=1
+ fprout=0
+ geomod=0
+ igbmod=0
+ igcmod=0
+ ijthsfwd=0.1
+ ijthsrev=0.1
+ jss=1.653e-007
+ jswgs=0
+ jsws=2.1207e-013
+ jtss=1e-011
+ jtsswgs=1e-011
+ jtssws=1e-011
+ k1=0.99870273
+ k2=-0.00067810868
+ k3=0
+ k3b=0
+ keta=-0.088919542
+ kt1=-0.29596713
+ kt1l=0
+ kt2=-0.020842369
+ ku0=0
+ kvsat=0
+ kvth0=0
+ la0=-1.4725376e-007
+ lags=-2.4436508e-009
+ lalpha0=-2.2830898e-012
+ lbeta0=-2.3737058e-006
+ level=54
+ lint=0
+ lk1=-3.5426364e-008
+ lk2=-1.7691446e-008
+ lketa=1.7668152e-008
+ lkt1=-8.3979897e-009
+ lkt2=2.1773833e-009
+ ll=0
+ lln=1
+ lmax=5e-007
+ lmin=2.8e-007
+ lpclm=5.0559583e-008
+ lpe0=3.2493e-008
+ lpeb=0
+ ltvoff=0
+ lu0=1.7890915e-009
+ lua=6.3071157e-016
+ lua1=-1.5583996e-016
+ lub=3.2915171e-026
+ lub1=-1.2857843e-025
+ luc=-7.439668e-018
+ luc1=8.8928926e-019
+ lvth0=-8.7733719e-009
+ lw=0
+ lwl=0
+ lwn=1
+ minv=-0.1
+ mjs=0.32084
+ mjswgs=0.21964
+ mjsws=0.05
+ mobmod=0
+ moin=15
+ ndep=5.6e+017
+ nfactor=0.8
+ ngate=6e+019
+ njs=1
+ njts=20
+ njtssw=20
+ njtsswg=20
+ noff=2.4
+ noia='pfet_03v3_noia'
+ noib='pfet_03v3_noib'
+ noic='pfet_03v3_noic'
+ nsd=1e+020
+ ntnoi=1
+ pa0=-1.5381528e-015
+ pags=9.42428e-014
+ palpha0=-8.3139811e-019
+ paramchk=1
+ pbeta0=-7.708444e-013
+ pbs=0.69939
+ pbswgs=0.65
+ pbsws=0.8022
+ pclm=0.32482036
+ pdiblc1=0.1484
+ pdiblc2=0.00073695
+ pdiblcb=0
+ pdits=0
+ pditsd=0
+ pditsl=0
+ permod=1
+ phin=0
+ pk2=-2.2709854e-015
+ pketa=1.9050111e-015
+ pkt1=4.2520201e-015
+ pkt2=-2.6564076e-015
+ ppclm=7.6023645e-016
+ prt=0
+ prwb=0
+ prwg=0
+ pscbe1=6.7448e+008
+ pscbe2=1e-005
+ ptvoff=0
+ pu0=-1.493953e-016
+ pua=1.0254352e-022
+ pua1=1.078475e-023
+ pub=-3.2981002e-031
+ pub1=-6.4708497e-032
+ puc=1.7732073e-023
+ puc1=-8.9106783e-024
+ pvag=0
+ pvth0=7.5670046e-015
+ rbodymod=0
+ rdsmod=0
+ rdsw=466
+ rdswmin=20
+ rgatemod=0
+ rsh=7
+ saref=4.4e-007
+ sbref=4.4e-007
+ tcj=0.00099187
+ tcjsw=0.00063483
+ tcjswg=0.000932
+ tnoimod=0
+ tnom=25
+ toxe=7.9e-009
+ toxm=7.9e-009
+ toxp=7.9e-009
+ toxref=7.9e-009
+ tpb=0.0016906
+ tpbsw=0.0052
+ tpbswg=0.000744
+ trnqsmod=0
+ tvoff=0.0032
+ u0=0.011352976
+ ua=3.4788822e-010
+ ua1=1.8116799e-009
+ ub=9.2772209e-019
+ ub1=-2.5843988e-018
+ uc=1.3375779e-010
+ uc1=-8.5778578e-011
+ ute=-1
+ vbm=-3
+ version=4.5
+ vfb=0
+ vfbcv=-1
+ voff=-0.097861
+ voffcv=-0.16
+ voffl=0
+ vsat=94000
+ vth0=-0.76226585
+ vtss=10
+ vtsswgs=10
+ vtssws=10
+ w0=2.5e-006
+ wa0=-7.0200638e-008
+ wags=-1.884856e-007
+ walpha0=2.4629388e-012
+ wbeta0=1.5361323e-006
+ wint=-1e-008
+ wk2=4.5419708e-009
+ wketa=-6.803611e-009
+ wkt1=-3.0216242e-008
+ wkt2=9.4871699e-009
+ wl=0
+ wln=1
+ wmax=1e-005
+ wmin=1.2e-006
+ wpclm=8.2952909e-008
+ wtvoff=0
+ wu0=-2.7989835e-009
+ wua=-4.7874691e-016
+ wua1=-2.1569499e-017
+ wub=4.3614967e-025
+ wub1=-1.0048507e-025
+ wuc=-7.0719038e-017
+ wuc1=1.7821357e-017
+ wvth0=4.2305517e-009
+ ww=0
+ wwl=0
+ wwn=1
+ xj=1e-007
+ xl=0
+ xpart=0
+ xtis=3
+ xw=0
.model pfet_03v3.9 pmos
+ a0=1.1782327
+ a1=0
+ a2=0.99
+ acde=1
+ acnqsmod=0
+ agidl=1.5908e-011
+ ags=0.20788505
+ alpha0=0.00011108151
+ alpha1=0
+ at=12000
+ b0=0
+ b1=0
+ beta0=43.187318
+ bgidl=1.3902e+009
+ binunit=2
+ capmod=2
+ cdsc=0.00024
+ cdscb=0
+ cdscd=0
+ cf=0
+ cgbo=1e-013
+ cgdl=4e-011
+ cgdo=1.24e-010
+ cgidl=7.5
+ cgsl=4e-011
+ cgso=1.24e-010
+ cit=0
+ cjs=0.00094344
+ cjswgs=4.794e-010
+ cjsws=1.5078e-010
+ ckappad=0.6
+ ckappas=0.6
+ clc=1e-007
+ cle=0.6
+ delta=0.01
+ diomod=1
+ dlc=-8e-009
+ dlcig=1.5e-007
+ dmcg=1.5e-007
+ drout=0.56
+ dsub=0.3659
+ dvt0=2.8985
+ dvt0w=0
+ dvt1=0.23999
+ dvt1w=5300000
+ dvt2=-0.016
+ dvt2w=-0.032
+ dvtp0=0
+ dvtp1=0
+ dwb=0
+ dwc=0
+ dwg=0
+ ef=1.12
+ egidl=0.1009
+ em=4.1e+007
+ epsrox=3.9
+ eta0=0.2541
+ etab=-0.15284
+ eu=1.67
+ fnoimod=1
+ fprout=0
+ geomod=0
+ igbmod=0
+ igcmod=0
+ ijthsfwd=0.1
+ ijthsrev=0.1
+ jss=1.653e-007
+ jswgs=0
+ jsws=2.1207e-013
+ jtss=1e-011
+ jtsswgs=1e-011
+ jtssws=1e-011
+ k1=0.97705
+ k2=-0.030551827
+ k3=0
+ k3b=0
+ keta=-0.0066799724
+ kt1=-0.30269355
+ kt1l=0
+ kt2=-0.010621998
+ ku0=0
+ kvsat=0
+ kvth0=0
+ la0=-2.9238479e-007
+ lags=6.0707474e-008
+ lalpha0=-5.296228e-011
+ lbeta0=-5.0643818e-006
+ level=54
+ lint=0
+ lk1=-2.46e-008
+ lk2=-2.7545864e-009
+ lketa=-2.3451633e-008
+ lkt1=-5.0347792e-009
+ lkt2=-2.9328019e-009
+ ll=0
+ lln=1
+ lmax=1.2e-006
+ lmin=5e-007
+ lpclm=2.407763e-008
+ lpdiblc2=2.4533143e-010
+ lpe0=3.2493e-008
+ lpeb=0
+ ltvoff=0
+ lu0=2.4020669e-009
+ lua=6.4174442e-016
+ lub=1.5676208e-026
+ lub1=-1.8989494e-025
+ luc=7.3318673e-017
+ luc1=-2.4594545e-017
+ lvoff=-1.787102e-009
+ lvth0=-7.1445584e-009
+ lw=0
+ lwl=0
+ lwn=1
+ minv=-0.1
+ mjs=0.32084
+ mjswgs=0.21964
+ mjsws=0.05
+ mobmod=0
+ moin=15
+ ndep=5.6e+017
+ nfactor=0.8
+ ngate=6e+019
+ njs=1
+ njts=20
+ njtssw=20
+ njtsswg=20
+ noff=2.4
+ noia='pfet_03v3_noia'
+ noib='pfet_03v3_noib'
+ noic='pfet_03v3_noic'
+ nsd=1e+020
+ ntnoi=1
+ pa0=-1.0756678e-013
+ pags=3.1315103e-015
+ palpha0=3.0672131e-018
+ paramchk=1
+ pbeta0=-4.7627532e-015
+ pbs=0.69939
+ pbswgs=0.65
+ pbsws=0.8022
+ pclm=0.37778426
+ pdiblc1=0.1484
+ pdiblc2=0.00024628714
+ pdiblcb=0
+ pdits=0
+ pditsd=0
+ pditsl=0
+ permod=1
+ phin=0
+ pk2=-3.0945989e-015
+ pketa=-2.5659333e-015
+ pkt1=-2.8909912e-014
+ pkt2=3.5780184e-015
+ ppclm=-3.006488e-014
+ prt=0
+ prwb=0
+ prwg=0
+ pscbe1=6.7448e+008
+ pscbe2=1e-005
+ ptvoff=0
+ pu0=-1.3347616e-015
+ pua=-1.0668567e-022
+ pub=-1.570756e-031
+ pub1=8.0252392e-032
+ puc=-3.0218479e-023
+ puc1=3.0005345e-023
+ pvag=0
+ pvoff=1.7906761e-014
+ pvth0=1.4216818e-014
+ rbodymod=0
+ rdsmod=0
+ rdsw=466
+ rdswmin=20
+ rgatemod=0
+ rsh=7
+ saref=4.4e-007
+ sbref=4.4e-007
+ tcj=0.00099187
+ tcjsw=0.00063483
+ tcjswg=0.000932
+ tnoimod=0
+ tnom=25
+ toxe=7.9e-009
+ toxm=7.9e-009
+ toxp=7.9e-009
+ toxref=7.9e-009
+ tpb=0.0016906
+ tpbsw=0.0052
+ tpbswg=0.000744
+ trnqsmod=0
+ tvoff=0.0032
+ u0=0.010127025
+ ua=3.2582253e-010
+ ua1=1.5e-009
+ ub=9.6220002e-019
+ ub1=-2.4617658e-018
+ uc=-2.7758895e-011
+ uc1=-3.4810909e-011
+ ute=-1
+ vbm=-3
+ version=4.5
+ vfb=0
+ vfbcv=-1
+ voff=-0.094286796
+ voffcv=-0.16
+ voffl=0
+ vsat=94000
+ vth0=-0.76552347
+ vtss=10
+ vtsswgs=10
+ vtssws=10
+ w0=2.5e-006
+ wa0=1.4185662e-007
+ wags=-6.2630205e-009
+ walpha0=-5.3342836e-012
+ wbeta0=3.968961e-009
+ wint=-1e-008
+ wk2=6.1891978e-009
+ wketa=2.1382778e-009
+ wkt1=3.6107623e-008
+ wkt2=-2.981682e-009
+ wl=0
+ wln=1
+ wmax=1e-005
+ wmin=1.2e-006
+ wpclm=1.4460314e-007
+ wtvoff=0
+ wu0=-4.282509e-010
+ wua=-6.0288518e-017
+ wub=9.0680837e-026
+ wub1=-3.9040685e-025
+ wuc=2.5182066e-017
+ wuc1=-6.0010691e-017
+ wvoff=-3.5813523e-008
+ wvth0=-9.069076e-009
+ ww=0
+ wwl=0
+ wwn=1
+ xj=1e-007
+ xl=0
+ xpart=0
+ xtis=3
+ xw=0
.model pfet_03v3.10 pmos
+ a0=1.1832393
+ a1=0
+ a2=0.99
+ acde=1
+ acnqsmod=0
+ agidl=1.5908e-011
+ ags=0.16685819
+ alpha0=0.0021426891
+ alpha1=0
+ at=12000
+ b0=0
+ b1=0
+ beta0=44.161948
+ bgidl=1.3902e+009
+ binunit=2
+ capmod=2
+ cdsc=0.00024
+ cdscb=0
+ cdscd=0
+ cf=0
+ cgbo=1e-013
+ cgdl=4e-011
+ cgdo=1.24e-010
+ cgidl=7.5
+ cgsl=4e-011
+ cgso=1.24e-010
+ cit=0
+ cjs=0.00094344
+ cjswgs=4.794e-010
+ cjsws=1.5078e-010
+ ckappad=0.6
+ ckappas=0.6
+ clc=1e-007
+ cle=0.6
+ delta=0.01
+ diomod=1
+ dlc=-8e-009
+ dlcig=1.5e-007
+ dmcg=1.5e-007
+ drout=0.56
+ dsub=0.3659
+ dvt0=2.8985
+ dvt0w=0
+ dvt1=0.23999
+ dvt1w=5300000
+ dvt2=-0.016
+ dvt2w=-0.032
+ dvtp0=0
+ dvtp1=0
+ dwb=0
+ dwc=0
+ dwg=0
+ ef=1.12
+ egidl=0.1009
+ em=4.1e+007
+ epsrox=3.9
+ eta0=0.2541
+ etab=-0.15284
+ eu=1.67
+ fnoimod=1
+ fprout=0
+ geomod=0
+ igbmod=0
+ igcmod=0
+ ijthsfwd=0.1
+ ijthsrev=0.1
+ jss=1.653e-007
+ jswgs=0
+ jsws=2.1207e-013
+ jtss=1e-011
+ jtsswgs=1e-011
+ jtssws=1e-011
+ k1=1.0137659
+ k2=-0.036023042
+ k3=0
+ k3b=0
+ keta=-0.0068224318
+ kt1=-0.29670927
+ kt1l=0
+ kt2=-0.012757219
+ ku0=0
+ kvsat=0
+ kvth0=0
+ la0=-2.9839274e-007
+ lags=1.0993971e-007
+ lalpha0=-2.4908914e-009
+ lbeta0=-6.233938e-006
+ level=54
+ lint=0
+ lk1=-6.8659091e-008
+ lk2=3.8108709e-009
+ lketa=-2.3280682e-008
+ lkt1=-1.2215919e-008
+ lkt2=-3.7053719e-010
+ ll=0
+ lln=1
+ lmax=1e-005
+ lmin=1.2e-006
+ lnoff=5.4545454e-007
+ lpclm=6.5657665e-008
+ lpdiblc2=4.4675455e-010
+ lpe0=3.2493e-008
+ lpeb=0
+ ltvoff=0
+ lu0=1.3166262e-009
+ lua=2.315961e-016
+ lua1=1.2483595e-016
+ lub1=4.4029649e-026
+ luc=5.9935909e-017
+ luc1=1.3542397e-017
+ lvoff=2.8431167e-009
+ lvoffcv=-2.1818182e-007
+ lvth0=-4.4690083e-009
+ lw=0
+ lwl=0
+ lwn=1
+ minv=-0.1
+ mjs=0.32084
+ mjswgs=0.21964
+ mjsws=0.05
+ mobmod=0
+ moin=15
+ ndep=5.6e+017
+ nfactor=0.8
+ ngate=6e+019
+ njs=1
+ njts=20
+ njtssw=20
+ njtsswg=20
+ noff=1.9454546
+ noia='pfet_03v3_noia'
+ noib='pfet_03v3_noib'
+ noic='pfet_03v3_noic'
+ nsd=1e+020
+ ntnoi=1
+ pa0=7.1205867e-014
+ pags=1.7427347e-015
+ palpha0=-3.7885537e-018
+ paramchk=1
+ pbeta0=-8.2590471e-013
+ pbs=0.69939
+ pbswgs=0.65
+ pbsws=0.8022
+ pclm=0.34313423
+ pdiblc1=0.1484
+ pdiblc2=7.8434545e-005
+ pdiblcb=0
+ pdits=0
+ pditsd=0
+ pditsl=0
+ permod=1
+ phin=0
+ pk2=-4.1863519e-016
+ pkt1=4.3700967e-014
+ pkt2=3.7127826e-015
+ ppclm=1.6302147e-013
+ prt=0
+ prwb=0
+ prwg=0
+ pscbe1=6.7448e+008
+ pscbe2=1e-005
+ ptvoff=0
+ pu0=4.0272326e-016
+ pua=2.7440495e-022
+ pua1=-1.5229986e-022
+ pub1=-4.4117708e-031
+ puc1=-6.6830088e-023
+ pvag=0
+ pvoff=-2.848803e-014
+ pvth0=3.7885537e-015
+ rbodymod=0
+ rdsmod=0
+ rdsw=466
+ rdswmin=20
+ rgatemod=0
+ rsh=7
+ saref=4.4e-007
+ sbref=4.4e-007
+ tcj=0.00099187
+ tcjsw=0.00063483
+ tcjswg=0.000932
+ tnoimod=0
+ tnom=25
+ toxe=7.9e-009
+ toxm=7.9e-009
+ toxp=7.9e-009
+ toxref=7.9e-009
+ tpb=0.0016906
+ tpbsw=0.0052
+ tpbswg=0.000744
+ trnqsmod=0
+ tvoff=0.0032
+ u0=0.011031559
+ ua=6.676128e-010
+ ua1=1.39597e-009
+ ub=9.7526352e-019
+ ub1=-2.656703e-018
+ uc=-1.6606591e-011
+ uc1=-6.6591694e-011
+ ute=-1
+ vbm=-3
+ version=4.5
+ vfb=0
+ vfbcv=-1
+ voff=-0.098145312
+ voffcv=0.021818182
+ voffl=0
+ vsat=94000
+ vth0=-0.7677531
+ vtss=10
+ vtsswgs=10
+ vtssws=10
+ w0=2.5e-006
+ wa0=-7.1205867e-009
+ wags=-5.1057076e-009
+ walpha0=3.7885537e-013
+ wbeta0=6.8825393e-007
+ wint=-1e-008
+ wk2=3.9592281e-009
+ wkt1=-2.4401443e-008
+ wkt2=-3.0939855e-009
+ wl=0
+ wln=1
+ wmax=1e-005
+ wmin=1.2e-006
+ wpclm=-1.6302147e-008
+ wtvoff=0
+ wu0=-1.8761549e-009
+ wua=-3.7786403e-016
+ wua1=1.2691655e-016
+ wub=-4.0215498e-026
+ wub1=4.4117708e-026
+ wuc1=2.0685503e-017
+ wvoff=2.848803e-009
+ wvth0=-3.7885537e-010
+ ww=0
+ wwl=0
+ wwn=1
+ xj=1e-007
+ xl=0
+ xpart=0
+ xtis=3
+ xw=0
.model pfet_03v3.11 pmos
+ a0=1.1534
+ a1=0
+ a2=0.99
+ acde=1
+ acnqsmod=0
+ agidl=1.5908e-011
+ ags=0.17785216
+ alpha0=0.0018936
+ alpha1=0
+ at=12000
+ b0=0
+ b1=0
+ beta0=43.538555
+ bgidl=1.3902e+009
+ binunit=2
+ capmod=2
+ cdsc=0.00024
+ cdscb=0
+ cdscd=0
+ cf=0
+ cgbo=1e-013
+ cgdl=4e-011
+ cgdo=1.24e-010
+ cgidl=7.5
+ cgsl=4e-011
+ cgso=1.24e-010
+ cit=0
+ cjs=0.00094344
+ cjswgs=4.794e-010
+ cjsws=1.5078e-010
+ ckappad=0.6
+ ckappas=0.6
+ clc=1e-007
+ cle=0.6
+ delta=0.01
+ diomod=1
+ dlc=-8e-009
+ dlcig=1.5e-007
+ dmcg=1.5e-007
+ drout=0.56
+ dsub=0.3659
+ dvt0=2.8985
+ dvt0w=0
+ dvt1=0.23999
+ dvt1w=5300000
+ dvt2=-0.016
+ dvt2w=-0.032
+ dvtp0=0
+ dvtp1=0
+ dwb=0
+ dwc=0
+ dwg=0
+ ef=1.12
+ egidl=0.1009
+ em=4.1e+007
+ epsrox=3.9
+ eta0=0.2541
+ etab=-0.15284
+ eu=1.67
+ fnoimod=1
+ fprout=0
+ geomod=0
+ igbmod=0
+ igcmod=0
+ ijthsfwd=0.1
+ ijthsrev=0.1
+ jss=1.653e-007
+ jswgs=0
+ jsws=2.1207e-013
+ jtss=1e-011
+ jtsswgs=1e-011
+ jtssws=1e-011
+ k1=1.0069
+ k2=-0.035641955
+ k3=0
+ k3b=0
+ keta=-0.0091505
+ kt1=-0.29793086
+ kt1l=0
+ kt2=-0.012794273
+ ku0=0
+ kvsat=0
+ kvth0=0
+ level=54
+ lint=0
+ ll=0
+ lln=1
+ lmax=5.0001e-005
+ lmin=1e-005
+ lpe0=3.2493e-008
+ lpeb=0
+ ltvoff=0
+ lw=0
+ lwl=0
+ lwn=1
+ minv=-0.1
+ mjs=0.32084
+ mjswgs=0.21964
+ mjsws=0.05
+ mobmod=0
+ moin=15
+ ndep=5.6e+017
+ nfactor=0.8
+ ngate=6e+019
+ njs=1
+ njts=20
+ njtssw=20
+ njtsswg=20
+ noff=2
+ noia='pfet_03v3_noia'
+ noib='pfet_03v3_noib'
+ noic='pfet_03v3_noic'
+ nsd=1e+020
+ ntnoi=1
+ paramchk=1
+ pbs=0.69939
+ pbswgs=0.65
+ pbsws=0.8022
+ pclm=0.3497
+ pdiblc1=0.1484
+ pdiblc2=0.00012311
+ pdiblcb=0
+ pdits=0
+ pditsd=0
+ pditsl=0
+ permod=1
+ phin=0
+ prt=0
+ prwb=0
+ prwg=0
+ pscbe1=6.7448e+008
+ pscbe2=1e-005
+ ptvoff=0
+ pvag=0
+ rbodymod=0
+ rdsmod=0
+ rdsw=466
+ rdswmin=20
+ rgatemod=0
+ rsh=7
+ saref=4.4e-007
+ sbref=4.4e-007
+ tcj=0.00099187
+ tcjsw=0.00063483
+ tcjswg=0.000932
+ tnoimod=0
+ tnom=25
+ toxe=7.9e-009
+ toxm=7.9e-009
+ toxp=7.9e-009
+ toxref=7.9e-009
+ tpb=0.0016906
+ tpbsw=0.0052
+ tpbswg=0.000744
+ trnqsmod=0
+ tvoff=0.0032
+ u0=0.011163222
+ ua=6.9077241e-010
+ ua1=1.4084536e-009
+ ub=9.7526352e-019
+ ub1=-2.6523e-018
+ uc=-1.0613e-011
+ uc1=-6.5237455e-011
+ ute=-1
+ vbm=-3
+ version=4.5
+ vfb=0
+ vfbcv=-1
+ voff=-0.097861
+ voffcv=0
+ voffl=0
+ vsat=94000
+ vth0=-0.7682
+ vtss=10
+ vtsswgs=10
+ vtssws=10
+ w0=2.5e-006
+ wags=-4.9314341e-009
+ wbeta0=6.0566345e-007
+ wint=-1e-008
+ wk2=3.9173646e-009
+ wkt1=-2.0031346e-008
+ wkt2=-2.7227073e-009
+ wl=0
+ wln=1
+ wmax=1e-005
+ wmin=1.2e-006
+ wtvoff=0
+ wu0=-1.8358826e-009
+ wua=-3.5042354e-016
+ wua1=1.1168656e-016
+ wub=-4.0215498e-026
+ wuc1=1.4002494e-017
+ ww=0
+ wwl=0
+ wwn=1
+ xj=1e-007
+ xl=0
+ xpart=0
+ xtis=3
+ xw=0
.model pfet_03v3.12 pmos
+ a0=0.88096455
+ a1=0
+ a2=0.99
+ acde=1
+ acnqsmod=0
+ agidl=1.5908e-011
+ ags=0.31537636
+ alpha0=9.9689273e-006
+ alpha1=0
+ at=12000
+ b0=0
+ b1=0
+ beta0=37.959273
+ bgidl=1.3902e+009
+ binunit=2
+ capmod=2
+ cdsc=0.00024
+ cdscb=0
+ cdscd=0
+ cf=0
+ cgbo=1e-013
+ cgdl=4e-011
+ cgdo=1.24e-010
+ cgidl=7.5
+ cgsl=4e-011
+ cgso=1.24e-010
+ cit=0
+ cjs=0.00094344
+ cjswgs=4.794e-010
+ cjsws=1.5078e-010
+ ckappad=0.6
+ ckappas=0.6
+ clc=1e-007
+ cle=0.6
+ delta=0.01
+ diomod=1
+ dlc=-8e-009
+ dlcig=1.5e-007
+ dmcg=1.5e-007
+ drout=0.56
+ dsub=0.3659
+ dvt0=2.8985
+ dvt0w=0
+ dvt1=0.23999
+ dvt1w=5300000
+ dvt2=-0.016
+ dvt2w=-0.032
+ dvtp0=0
+ dvtp1=0
+ dwb=0
+ dwc=0
+ dwg=0
+ ef=1.12
+ egidl=0.1009
+ em=4.1e+007
+ epsrox=3.9
+ eta0=0.2541
+ etab=-0.15284
+ eu=1.67
+ fnoimod=1
+ fprout=0
+ geomod=0
+ igbmod=0
+ igcmod=0
+ ijthsfwd=0.1
+ ijthsrev=0.1
+ jss=1.653e-007
+ jswgs=0
+ jsws=2.1207e-013
+ jtss=1e-011
+ jtsswgs=1e-011
+ jtssws=1e-011
+ k1=0.99870273
+ k2=-0.00022481818
+ k3=0
+ k3b=0
+ keta=-0.089598545
+ kt1=-0.29898273
+ kt1l=0
+ kt2=-0.019895546
+ ku0=0
+ kvsat=0
+ kvth0=0
+ la0=-1.4740727e-007
+ lags=6.9618182e-009
+ lalpha0=-2.3660636e-012
+ lbeta0=-2.4506364e-006
+ level=54
+ lint=0
+ lk1=-3.5426364e-008
+ lk2=-1.7918091e-008
+ lketa=1.7858273e-008
+ lkt1=-7.9736364e-009
+ lkt2=1.9122727e-009
+ ll=0
+ lln=1
+ lmax=5e-007
+ lmin=2.8e-007
+ lpclm=5.0635454e-008
+ lpe0=3.2493e-008
+ lpeb=0
+ ltvoff=0
+ lu0=1.7741818e-009
+ lua=6.4094546e-016
+ lua1=-1.5476364e-016
+ lub1=-1.3503636e-025
+ luc=-5.67e-018
+ lvth0=-8.0181818e-009
+ lw=0
+ lwl=0
+ lwn=1
+ minv=-0.1
+ mjs=0.32084
+ mjswgs=0.21964
+ mjsws=0.05
+ mobmod=0
+ moin=15
+ ndep=5.6e+017
+ nfactor=0.8
+ ngate=6e+019
+ njs=1
+ njts=20
+ njtssw=20
+ njtsswg=20
+ noff=2.4
+ noia='pfet_03v3_noia'
+ noib='pfet_03v3_noib'
+ noic='pfet_03v3_noic'
+ nsd=1e+020
+ ntnoi=1
+ paramchk=1
+ pbs=0.69939
+ pbswgs=0.65
+ pbsws=0.8022
+ pclm=0.33309909
+ pdiblc1=0.1484
+ pdiblc2=0.00073695
+ pdiblcb=0
+ pdits=0
+ pditsd=0
+ pditsl=0
+ permod=1
+ phin=0
+ prt=0
+ prwb=0
+ prwg=0
+ pscbe1=6.7448e+008
+ pscbe2=1e-005
+ ptvoff=0
+ pvag=0
+ rbodymod=0
+ rdsmod=0
+ rdsw=466
+ rdswmin=20
+ rgatemod=0
+ rsh=7
+ saref=4.4e-007
+ sbref=4.4e-007
+ tcj=0.00099187
+ tcjsw=0.00063483
+ tcjswg=0.000932
+ tnoimod=0
+ tnom=25
+ toxe=7.9e-009
+ toxm=7.9e-009
+ toxp=7.9e-009
+ toxref=7.9e-009
+ tpb=0.0016906
+ tpbsw=0.0052
+ tpbswg=0.000744
+ trnqsmod=0
+ tvoff=0.0032
+ u0=0.011073636
+ ua=3.0010909e-010
+ ua1=1.8095273e-009
+ ub=9.7125e-019
+ ub1=-2.5944273e-018
+ uc=1.267e-010
+ uc1=-8.4e-011
+ ute=-1
+ vbm=-3
+ version=4.5
+ vfb=0
+ vfbcv=-1
+ voff=-0.097861
+ voffcv=-0.16
+ voffl=0
+ vsat=94000
+ vth0=-0.76184364
+ vtss=10
+ vtsswgs=10
+ vtssws=10
+ w0=2.5e-006
+ wint=-1e-008
+ wl=0
+ wln=1
+ wmax=0.000100001
+ wmin=1e-005
+ wtvoff=0
+ ww=0
+ wwl=0
+ wwn=1
+ xj=1e-007
+ xl=0
+ xpart=0
+ xtis=3
+ xw=0
.model pfet_03v3.13 pmos
+ a0=1.19239
+ a1=0
+ a2=0.99
+ acde=1
+ acnqsmod=0
+ agidl=1.5908e-011
+ ags=0.20726
+ alpha0=0.00011054914
+ alpha1=0
+ at=12000
+ b0=0
+ b1=0
+ beta0=43.187714
+ bgidl=1.3902e+009
+ binunit=2
+ capmod=2
+ cdsc=0.00024
+ cdscb=0
+ cdscd=0
+ cf=0
+ cgbo=1e-013
+ cgdl=4e-011
+ cgdo=1.24e-010
+ cgidl=7.5
+ cgsl=4e-011
+ cgso=1.24e-010
+ cit=0
+ cjs=0.00094344
+ cjswgs=4.794e-010
+ cjsws=1.5078e-010
+ ckappad=0.6
+ ckappas=0.6
+ clc=1e-007
+ cle=0.6
+ delta=0.01
+ diomod=1
+ dlc=-8e-009
+ dlcig=1.5e-007
+ dmcg=1.5e-007
+ drout=0.56
+ dsub=0.3659
+ dvt0=2.8985
+ dvt0w=0
+ dvt1=0.23999
+ dvt1w=5300000
+ dvt2=-0.016
+ dvt2w=-0.032
+ dvtp0=0
+ dvtp1=0
+ dwb=0
+ dwc=0
+ dwg=0
+ ef=1.12
+ egidl=0.1009
+ em=4.1e+007
+ epsrox=3.9
+ eta0=0.2541
+ etab=-0.15284
+ eu=1.67
+ fnoimod=1
+ fprout=0
+ geomod=0
+ igbmod=0
+ igcmod=0
+ ijthsfwd=0.1
+ ijthsrev=0.1
+ jss=1.653e-007
+ jswgs=0
+ jsws=2.1207e-013
+ jtss=1e-011
+ jtsswgs=1e-011
+ jtssws=1e-011
+ k1=0.97705
+ k2=-0.029934143
+ k3=0
+ k3b=0
+ keta=-0.0064665714
+ kt1=-0.29909
+ kt1l=0
+ kt2=-0.010919571
+ ku0=0
+ kvsat=0
+ kvth0=0
+ la0=-3.0312e-007
+ lags=6.102e-008
+ lalpha0=-5.2656171e-011
+ lbeta0=-5.0648571e-006
+ level=54
+ lint=0
+ lk1=-2.46e-008
+ lk2=-3.0634286e-009
+ lketa=-2.3707714e-008
+ lkt1=-7.92e-009
+ lkt2=-2.5757143e-009
+ ll=0
+ lln=1
+ lmax=1.2e-006
+ lmin=5e-007
+ lpclm=2.1077143e-008
+ lpdiblc2=2.4533143e-010
+ lpe0=3.2493e-008
+ lpeb=0
+ ltvoff=0
+ lu0=2.2688571e-009
+ lua=6.3109714e-016
+ lub1=-1.8188571e-025
+ luc=7.0302857e-017
+ luc1=-2.16e-017
+ lvth0=-5.7257143e-009
+ lw=0
+ lwl=0
+ lwn=1
+ minv=-0.1
+ mjs=0.32084
+ mjswgs=0.21964
+ mjsws=0.05
+ mobmod=0
+ moin=15
+ ndep=5.6e+017
+ nfactor=0.8
+ ngate=6e+019
+ njs=1
+ njts=20
+ njtssw=20
+ njtsswg=20
+ noff=2.4
+ noia='pfet_03v3_noia'
+ noib='pfet_03v3_noib'
+ noic='pfet_03v3_noic'
+ nsd=1e+020
+ ntnoi=1
+ paramchk=1
+ pbs=0.69939
+ pbswgs=0.65
+ pbsws=0.8022
+ pclm=0.39221571
+ pdiblc1=0.1484
+ pdiblc2=0.00024628714
+ pdiblcb=0
+ pdits=0
+ pditsd=0
+ pditsl=0
+ permod=1
+ phin=0
+ prt=0
+ prwb=0
+ prwg=0
+ pscbe1=6.7448e+008
+ pscbe2=1e-005
+ ptvoff=0
+ pvag=0
+ rbodymod=0
+ rdsmod=0
+ rdsw=466
+ rdswmin=20
+ rgatemod=0
+ rsh=7
+ saref=4.4e-007
+ sbref=4.4e-007
+ tcj=0.00099187
+ tcjsw=0.00063483
+ tcjswg=0.000932
+ tnoimod=0
+ tnom=25
+ toxe=7.9e-009
+ toxm=7.9e-009
+ toxp=7.9e-009
+ toxref=7.9e-009
+ tpb=0.0016906
+ tpbsw=0.0052
+ tpbswg=0.000744
+ trnqsmod=0
+ tvoff=0.0032
+ u0=0.010084286
+ ua=3.1980571e-010
+ ua1=1.5e-009
+ ub=9.7125e-019
+ ub1=-2.5007286e-018
+ uc=-2.5245714e-011
+ uc1=-4.08e-011
+ ute=-1
+ vbm=-3
+ version=4.5
+ vfb=0
+ vfbcv=-1
+ voff=-0.097861
+ voffcv=-0.16
+ voffl=0
+ vsat=94000
+ vth0=-0.76642857
+ vtss=10
+ vtsswgs=10
+ vtssws=10
+ w0=2.5e-006
+ wint=-1e-008
+ wl=0
+ wln=1
+ wmax=0.000100001
+ wmin=1e-005
+ wtvoff=0
+ ww=0
+ wwl=0
+ wwn=1
+ xj=1e-007
+ xl=0
+ xpart=0
+ xtis=3
+ xw=0
.model pfet_03v3.14 pmos
+ a0=1.1825286
+ a1=0
+ a2=0.99
+ acde=1
+ acnqsmod=0
+ agidl=1.5908e-011
+ ags=0.16634864
+ alpha0=0.002142727
+ alpha1=0
+ at=12000
+ b0=0
+ b1=0
+ beta0=44.230636
+ bgidl=1.3902e+009
+ binunit=2
+ capmod=2
+ cdsc=0.00024
+ cdscb=0
+ cdscd=0
+ cf=0
+ cgbo=1e-013
+ cgdl=4e-011
+ cgdo=1.24e-010
+ cgidl=7.5
+ cgsl=4e-011
+ cgso=1.24e-010
+ cit=0
+ cjs=0.00094344
+ cjswgs=4.794e-010
+ cjsws=1.5078e-010
+ ckappad=0.6
+ ckappas=0.6
+ clc=1e-007
+ cle=0.6
+ delta=0.01
+ diomod=1
+ dlc=-8e-009
+ dlcig=1.5e-007
+ dmcg=1.5e-007
+ drout=0.56
+ dsub=0.3659
+ dvt0=2.8985
+ dvt0w=0
+ dvt1=0.23999
+ dvt1w=5300000
+ dvt2=-0.016
+ dvt2w=-0.032
+ dvtp0=0
+ dvtp1=0
+ dwb=0
+ dwc=0
+ dwg=0
+ ef=1.12
+ egidl=0.1009
+ em=4.1e+007
+ epsrox=3.9
+ eta0=0.2541
+ etab=-0.15284
+ eu=1.67
+ fnoimod=1
+ fprout=0
+ geomod=0
+ igbmod=0
+ igcmod=0
+ ijthsfwd=0.1
+ ijthsrev=0.1
+ jss=1.653e-007
+ jswgs=0
+ jsws=2.1207e-013
+ jtss=1e-011
+ jtsswgs=1e-011
+ jtssws=1e-011
+ k1=1.0137659
+ k2=-0.035627909
+ k3=0
+ k3b=0
+ keta=-0.0068224318
+ kt1=-0.29914454
+ kt1l=0
+ kt2=-0.013066
+ ku0=0
+ kvsat=0
+ kvth0=0
+ la0=-2.9128636e-007
+ lags=1.1011364e-007
+ lalpha0=-2.4912696e-009
+ lbeta0=-6.3163636e-006
+ level=54
+ lint=0
+ lk1=-6.8659091e-008
+ lk2=3.7690909e-009
+ lketa=-2.3280682e-008
+ lkt1=-7.8545455e-009
+ ll=0
+ lln=1
+ lmax=1e-005
+ lmin=1.2e-006
+ lnoff=5.4545454e-007
+ lpclm=8.1927273e-008
+ lpdiblc2=4.4675455e-010
+ lpe0=3.2493e-008
+ lpeb=0
+ ltvoff=0
+ lu0=1.3568182e-009
+ lua=2.5898182e-016
+ lua1=1.0963636e-016
+ luc=5.9935909e-017
+ luc1=6.8727273e-018
+ lvoffcv=-2.1818182e-007
+ lvth0=-4.0909091e-009
+ lw=0
+ lwl=0
+ lwn=1
+ minv=-0.1
+ mjs=0.32084
+ mjswgs=0.21964
+ mjsws=0.05
+ mobmod=0
+ moin=15
+ ndep=5.6e+017
+ nfactor=0.8
+ ngate=6e+019
+ njs=1
+ njts=20
+ njtssw=20
+ njtsswg=20
+ noff=1.9454546
+ noia='pfet_03v3_noia'
+ noib='pfet_03v3_noib'
+ noic='pfet_03v3_noic'
+ nsd=1e+020
+ ntnoi=1
+ paramchk=1
+ pbs=0.69939
+ pbswgs=0.65
+ pbsws=0.8022
+ pclm=0.34150727
+ pdiblc1=0.1484
+ pdiblc2=7.8434545e-005
+ pdiblcb=0
+ pdits=0
+ pditsd=0
+ pditsl=0
+ permod=1
+ phin=0
+ prt=0
+ prwb=0
+ prwg=0
+ pscbe1=6.7448e+008
+ pscbe2=1e-005
+ ptvoff=0
+ pvag=0
+ rbodymod=0
+ rdsmod=0
+ rdsw=466
+ rdswmin=20
+ rgatemod=0
+ rsh=7
+ saref=4.4e-007
+ sbref=4.4e-007
+ tcj=0.00099187
+ tcjsw=0.00063483
+ tcjswg=0.000932
+ tnoimod=0
+ tnom=25
+ toxe=7.9e-009
+ toxm=7.9e-009
+ toxp=7.9e-009
+ toxref=7.9e-009
+ tpb=0.0016906
+ tpbsw=0.0052
+ tpbswg=0.000744
+ trnqsmod=0
+ tvoff=0.0032
+ u0=0.010844318
+ ua=6.2990182e-010
+ ua1=1.4086364e-009
+ ub=9.7125e-019
+ ub1=-2.6523e-018
+ uc=-1.6606591e-011
+ uc1=-6.4527273e-011
+ ute=-1
+ vbm=-3
+ version=4.5
+ vfb=0
+ vfbcv=-1
+ voff=-0.097861
+ voffcv=0.021818182
+ voffl=0
+ vsat=94000
+ vth0=-0.76779091
+ vtss=10
+ vtsswgs=10
+ vtssws=10
+ w0=2.5e-006
+ wint=-1e-008
+ wl=0
+ wln=1
+ wmax=0.000100001
+ wmin=1e-005
+ wtvoff=0
+ ww=0
+ wwl=0
+ wwn=1
+ xj=1e-007
+ xl=0
+ xpart=0
+ xtis=3
+ xw=0
.model pfet_03v3.15 pmos
+ a0=1.1534
+ a1=0
+ a2=0.99
+ acde=1
+ acnqsmod=0
+ agidl=1.5908e-011
+ ags=0.17736
+ alpha0=0.0018936
+ alpha1=0
+ at=12000
+ b0=0
+ b1=0
+ beta0=43.599
+ bgidl=1.3902e+009
+ binunit=2
+ capmod=2
+ cdsc=0.00024
+ cdscb=0
+ cdscd=0
+ cf=0
+ cgbo=1e-013
+ cgdl=4e-011
+ cgdo=1.24e-010
+ cgidl=7.5
+ cgsl=4e-011
+ cgso=1.24e-010
+ cit=0
+ cjs=0.00094344
+ cjswgs=4.794e-010
+ cjsws=1.5078e-010
+ ckappad=0.6
+ ckappas=0.6
+ clc=1e-007
+ cle=0.6
+ delta=0.01
+ diomod=1
+ dlc=-8e-009
+ dlcig=1.5e-007
+ dmcg=1.5e-007
+ drout=0.56
+ dsub=0.3659
+ dvt0=2.8985
+ dvt0w=0
+ dvt1=0.23999
+ dvt1w=5300000
+ dvt2=-0.016
+ dvt2w=-0.032
+ dvtp0=0
+ dvtp1=0
+ dwb=0
+ dwc=0
+ dwg=0
+ ef=1.12
+ egidl=0.1009
+ em=4.1e+007
+ epsrox=3.9
+ eta0=0.2541
+ etab=-0.15284
+ eu=1.67
+ fnoimod=1
+ fprout=0
+ geomod=0
+ igbmod=0
+ igcmod=0
+ ijthsfwd=0.1
+ ijthsrev=0.1
+ jss=1.653e-007
+ jswgs=0
+ jsws=2.1207e-013
+ jtss=1e-011
+ jtsswgs=1e-011
+ jtssws=1e-011
+ k1=1.0069
+ k2=-0.035251
+ k3=0
+ k3b=0
+ keta=-0.0091505
+ kt1=-0.29993
+ kt1l=0
+ kt2=-0.013066
+ ku0=0
+ kvsat=0
+ kvth0=0
+ level=54
+ lint=0
+ ll=0
+ lln=1
+ lmax=5.0001e-005
+ lmin=1e-005
+ lpe0=3.2493e-008
+ lpeb=0
+ ltvoff=0
+ lw=0
+ lwl=0
+ lwn=1
+ minv=-0.1
+ mjs=0.32084
+ mjswgs=0.21964
+ mjsws=0.05
+ mobmod=0
+ moin=15
+ ndep=5.6e+017
+ nfactor=0.8
+ ngate=6e+019
+ njs=1
+ njts=20
+ njtssw=20
+ njtsswg=20
+ noff=2
+ noia='pfet_03v3_noia'
+ noib='pfet_03v3_noib'
+ noic='pfet_03v3_noic'
+ nsd=1e+020
+ ntnoi=1
+ paramchk=1
+ pbs=0.69939
+ pbswgs=0.65
+ pbsws=0.8022
+ pclm=0.3497
+ pdiblc1=0.1484
+ pdiblc2=0.00012311
+ pdiblcb=0
+ pdits=0
+ pditsd=0
+ pditsl=0
+ permod=1
+ phin=0
+ prt=0
+ prwb=0
+ prwg=0
+ pscbe1=6.7448e+008
+ pscbe2=1e-005
+ ptvoff=0
+ pvag=0
+ rbodymod=0
+ rdsmod=0
+ rdsw=466
+ rdswmin=20
+ rgatemod=0
+ rsh=7
+ saref=4.4e-007
+ sbref=4.4e-007
+ tcj=0.00099187
+ tcjsw=0.00063483
+ tcjswg=0.000932
+ tnoimod=0
+ tnom=25
+ toxe=7.9e-009
+ toxm=7.9e-009
+ toxp=7.9e-009
+ toxref=7.9e-009
+ tpb=0.0016906
+ tpbsw=0.0052
+ tpbswg=0.000744
+ trnqsmod=0
+ tvoff=0.0032
+ u0=0.01098
+ ua=6.558e-010
+ ua1=1.4196e-009
+ ub=9.7125e-019
+ ub1=-2.6523e-018
+ uc=-1.0613e-011
+ uc1=-6.384e-011
+ ute=-1
+ vbm=-3
+ version=4.5
+ vfb=0
+ vfbcv=-1
+ voff=-0.097861
+ voffcv=0
+ voffl=0
+ vsat=94000
+ vth0=-0.7682
+ vtss=10
+ vtsswgs=10
+ vtssws=10
+ w0=2.5e-006
+ wint=-1e-008
+ wl=0
+ wln=1
+ wmax=0.000100001
+ wmin=1e-005
+ wtvoff=0
+ ww=0
+ wwl=0
+ wwn=1
+ xj=1e-007
+ xl=0
+ xpart=0
+ xtis=3
+ xw=0
.subckt pplus_u_m1 1 2 3 lr=lr wr=wr dtemp=0 par=1 r_rsh0=rsh_pplus_u_m r_dw=2.75e-8 r_dl=0 r_vc1=0 r_vc2=0 r_tc1=1.375e-3 r_tc2=1e-6 r_tnom=25 r_l='lr-2*r_dl' r_w='wr-2*r_dw' r_n='r_l/r_w' r_temp='1+r_tc1*(temper+dtemp-r_tnom)+r_tc2*(temper+dtemp-r_tnom)*(temper+dtemp-r_tnom)'
.model pn_junction d
+ cj=0.00094344
+ cjsw=1.5078e-010
+ cta=0.00099187
+ ctp=0.00063483
+ level=3
+ mj=0.32084
+ mjsw=0.05
+ pb=0.69939
+ php=0.8022
+ tlevc=1
+ tpb=0.0016906
+ tphp=0.0058423
+ tref=25
d1 1 3 pn_junction area='r_w*r_l' pj='2*(r_w+r_l)'
rb 1 2 r='r_temp*r_n*(r_rsh0+r_vc1*abs(v(1,2))/r_n+r_vc2*abs(v(1,2))*abs(v(1,2))/r_n/r_n)'
.ends pplus_u_m1
.param rsh_nplus_u_m=60
.param rsh_pplus_u_m=185
.param nfet_06v0_vsat=1
.param nfet_06v0_vth0=0
.param nfet_06v0_xl=0
.param nfet_06v0_xw=0
.param nfet_06v0_tox=0
.param nfet_06v0_cgso=1
.param nfet_06v0_cgdo=1
.param nfet_06v0_nvt_u0=0.070102
.param nfet_06v0_nvt_vth0=-0.039
.param nfet_06v0_nvt_xl=0
.param nfet_06v0_nvt_xw=0
.param nfet_06v0_nvt_tox=1.52e-008
.param nfet_06v0_nvt_cgso=1e-010
.param nfet_06v0_nvt_cgdo=1e-010
.param pfet_06v0_dvth0=0
.param pfet_06v0_dxl=0
.param pfet_06v0_dxw=0
.param pfet_06v0_dtox=0
.param pfet_06v0_dcgdo=1
.param pfet_06v0_dcgso=1
.subckt nfet_06v0_dss d g s b w=10u l=0.6u nf=1 m=1 par=1 s_sab=0.28u d_sab=3.78u as=0 ad=0 ps=0 pd=0 nrd=0 nrs=0 dtemp=0 sa=0 sb=0 sd=0
.param par_vth=0.01155
.param par_k=0.0000
.param par_l=4e-7
.param par_w=-5e-7
.param par_leff='l-par_l'
.param par_weff='par*(w-par_w)'
.param p_sqrtarea='sqrt((par_leff)*(par_weff))'
.param var_k='0.7071*par_k*1e-06/p_sqrtarea'
.param mis_k='agauss(0,var_k,1)'
.param var_vth='0.7071*par_vth*1e-06/p_sqrtarea'
.param mis_vth='agauss(0,var_vth,1)'
xr1 d d1 b nplus_u_m2 wr='w' lr='(d_sab==0)?1e-15:d_sab'
xr2 s s1 b nplus_u_m2 wr='w' lr='(s_sab==0)?1e-15:s_sab'
m0 d1 g s1 b nfet_06v0 ad=ad as=as delvto='mis_vth*sw_stat_mismatch' l='l' m=m mulu0='1-mis_k*sw_stat_mismatch' nf=nf nrd=nrd nrs=nrs pd=pd ps=ps sa=0 sb=0 sd=0 w='w'
.ends
.model nfet_06v0.0 nmos
+ a0=0.72499969
+ a1=0
+ a2=0.96
+ acde=0.3
+ acnqsmod=0
+ agidl=0
+ ags=0.13699995
+ aigbacc=0.43
+ aigbinv=0.35
+ aigc=0.43
+ aigsd=0.43
+ alpha0=-1.88e-007
+ alpha1=19
+ at=109000.03
+ b0=0
+ b1=0
+ beta0=36.6
+ bgidl=2.3e+009
+ bigbacc=0.054
+ bigbinv=0.03
+ bigc=0.054
+ bigsd=0.054
+ binunit=1
+ bvs=11
+ capmod=2
+ cdsc=0.00024
+ cdscb=0
+ cdscd=0
+ cgbo=1e-013
+ cgdl='1.5e-010*nfet_06v0_cgdo'
+ cgdo='1e-010*nfet_06v0_cgdo'
+ cgidl=0.5
+ cgsl='1.5e-010*nfet_06v0_cgso'
+ cgso='1e-010*nfet_06v0_cgso'
+ cigbacc=0.075
+ cigbinv=0.006
+ cigc=0.075
+ cigsd=0.075
+ cit=0
+ cjs=0.00095
+ cjswgs=3.573e-010
+ cjsws=1.33e-010
+ ckappad=0.6
+ ckappas=0.6
+ clc=1e-010
+ cle=0.6
+ delta=0.01
+ diomod=1
+ dlc=5.4e-8
+ dlcig=0
+ dmcg=0
+ dmcgt=0
+ dmdg=0
+ drout=0.4
+ dsub=0.4
+ dvt0=5.72
+ dvt0w=10
+ dvt1=0.299
+ dvt1w=976700
+ dvt2=-0.0793
+ dvt2w=0.15
+ dvtp0=0
+ dvtp1=0
+ dwb=6e-009
+ dwc=0
+ dwg=-6e-010
+ ef=1
+ egidl=0.8
+ eigbinv=1.1
+ em=4.1e+007
+ epsrox=3.9
+ eta0=0
+ etab=-0.43
+ eu=1.67
+ fnoimod=1
+ fprout=0
+ gbmin=1e-012
+ geomod=0
+ igbmod=0
+ igcmod=0
+ ijthsfwd=0.1
+ ijthsrev=0.1
+ jss=6.88e-007
+ jswgs=0
+ jsws=4.88e-013
+ jtsd=0
+ jtss=0
+ jtsswd=0
+ jtsswgd=0
+ jtsswgs=0
+ jtssws=0
+ k1=0.9
+ k2=-0.001
+ k2we=0
+ k3=-1.1369995
+ k3b=0.86
+ keta=-0.021200021
+ kt1=-0.412
+ kt1l=3.5e-008
+ kt2=-0.05
+ ku0=0
+ ku0we=0
+ kvsat=0
+ kvth0=0
+ kvth0we=0
+ la0=0.40144032
+ lags=-0.068999933
+ lambda=0
+ lat=-75600.021
+ level=54
+ lint=-3e-008
+ lintnoi=0
+ lketa=0.04140001
+ lku0=0
+ lkvth0=0
+ ll=1.93e-014
+ llc=0
+ lln=1
+ llodku0=0
+ llodvth=0
+ lmax=5.0001e-005
+ lmin=7e-007
+ lodeta0=1
+ lodk2=1
+ lp=1e-008
+ lpclm=0.89088024
+ lpe0=1.63e-007
+ lpeb=0
+ lu0=0.019999998
+ lua=-3.3696895e-019
+ lub=1.7400001e-018
+ luc=9.8000018e-011
+ luc1=-1.8816003e-011
+ lute=0.030000222
+ lvsat='-2649.9871*nfet_06v0_vsat'
+ lw=0
+ lwc=0
+ lwl=0
+ lwlc=0
+ lwn=1
+ minv=0
+ mjs=0.296
+ mjswgs=0.40313
+ mjsws=0.01
+ mobmod=0
+ moin=15
+ ndep=1.7e+017
+ nfactor=0.864
+ ngate=1e+020
+ ngcon=1
+ nigbacc=1
+ nigbinv=3
+ nigc=1
+ njs=1.0541
+ njts=20
+ njtssw=20
+ njtsswg=20
+ noff=1.5
+ noia='nfet_06v0_noia'
+ noib='nfet_06v0_noib'
+ noic='nfet_06v0_noic'
+ nsd=1e+020
+ ntnoi=1
+ ntox=1
+ pags=0.0070910278
+ paramchk=1
+ pat=-6699.9857
+ pbs=0.606
+ pbswgs=0.861
+ pbsws=0.48
+ pclm=0.0099999763
+ pdiblc1=1.6
+ pdiblc2=0.0022
+ pdiblcb=0
+ pdits=0
+ pditsd=0
+ pditsl=0
+ permod=1
+ phin=0
+ pigcd=1
+ pku0=0
+ pkvth0=0
+ poxedge=1
+ prt=0
+ prwb=0
+ prwg=1
+ pscbe1=4.325e+009
+ pscbe2=8.8e-006
+ pu0=0.0018000065
+ pua=1.4622721e-010
+ pub=-2.3803999e-019
+ puc=-5.6168065e-012
+ pute=-0.019999981
+ pvag=1.75
+ pvsat='6308.7992*nfet_06v0_vsat'
+ rbdb=50
+ rbdbx0=100
+ rbdby0=100
+ rbodymod=0
+ rbpb=50
+ rbpbx0=100
+ rbpbxl=0
+ rbpbxnf=0
+ rbpbxw=0
+ rbpby0=100
+ rbpbyl=0
+ rbpbynf=0
+ rbpbyw=0
+ rbpd=50
+ rbpd0=50
+ rbpdl=0
+ rbpdnf=0
+ rbpdw=0
+ rbps=50
+ rbps0=50
+ rbpsl=0
+ rbpsnf=0
+ rbpsw=0
+ rbsb=50
+ rbsbx0=100
+ rbsby0=100
+ rbsdbxl=0
+ rbsdbxnf=0
+ rbsdbxw=0
+ rbsdbyl=0
+ rbsdbynf=0
+ rbsdbyw=0
+ rdsmod=0
+ rdsw=2175
+ rdswmin=0
+ rdw=100
+ rdwmin=0
+ rgatemod=0
+ rgeomod=0
+ rsh=7
+ rshg=0.1
+ rsw=100
+ rswmin=0
+ saref=1e-006
+ sbref=1e-006
+ scref=1e-006
+ steta0=0
+ stk2=0
+ tcj=0.000825
+ tcjsw=0.0018
+ tcjswg=0.001595
+ tempmod=0
+ tku0=0
+ tnjts=0
+ tnjtssw=0
+ tnjtsswg=0
+ tnoimod=0
+ tnom=25
+ toxe='1.52e-008+nfet_06v0_tox'
+ toxm='1.52e-008+nfet_06v0_tox'
+ toxp='1.6e-008+nfet_06v0_tox'
+ toxref=1.52e-008
+ tpb=0.00146
+ tpbsw=0.00313
+ tpbswg=0.0016588
+ trnqsmod=0
+ tvfbsdoff=0
+ tvoff=0
+ u0=0.052500014
+ ua=6.8000001e-012
+ ua1=1e-009
+ ub=2.8799997e-018
+ ub1=-1e-018
+ uc=7.9399996e-011
+ uc1=-5.5999995e-011
+ ud1=0
+ up=0
+ ute=-1.5000005
+ vbm=-3
+ version=4.5
+ vfbcv=-1
+ vfbsdoff=0
+ voff=-0.08
+ voffcv=0
+ voffl=0
+ vsat='103999.98*nfet_06v0_vsat'
+ vth0='0.67314+nfet_06v0_vth0'
+ vtl=200000
+ vtsd=10
+ vtss=10
+ vtsswd=10
+ vtsswgd=10
+ vtsswgs=10
+ vtssws=10
+ w0=1e-009
+ wags=-4.2211594e-008
+ wat=6479.9797
+ web=0
+ wec=0
+ wint=1.55e-008
+ wk3=-0.047531062
+ wku0=0
+ wkvth0=0
+ wl=0
+ wlc=0
+ wln=1
+ wlod=0
+ wlodku0=0
+ wlodvth=0
+ wmax=0.000100001
+ wmin=3e-007
+ wpemod=0
+ wr=1
+ wu0=-8.0300635e-009
+ wua=-8.4912706e-019
+ wub=-1.1655759e-026
+ wuc=8.0000028e-012
+ wute=0.06000001
+ wvsat='0.012447116*nfet_06v0_vsat'
+ ww=-2.7e-015
+ wwc=0
+ wwl=0
+ wwlc=0
+ wwn=1
+ xgl=0
+ xgw=0
+ xj=1.5e-007
+ xjbvd=1
+ xjbvs=1
+ xl='0+nfet_06v0_xl'
+ xn=3
+ xpart=0
+ xrcrg1=12
+ xrcrg2=1
+ xtis=3
+ xtsd=0.02
+ xtss=0.02
+ xtsswd=0.02
+ xtsswgd=0.02
+ xtsswgs=0.02
+ xtssws=0.02
+ xw='0+nfet_06v0_xw'
.model nfet_06v0.1 nmos
+ a0=0.72500081
+ a1=0
+ a2=0.96
+ acde=0.3
+ acnqsmod=0
+ agidl=0
+ ags=0.13700019
+ aigbacc=0.43
+ aigbinv=0.35
+ aigc=0.43
+ aigsd=0.43
+ alpha0=-1.88e-007
+ alpha1=19
+ at=-119957.68
+ b0=0
+ b1=0
+ beta0=36.6
+ bgidl=2.3e+009
+ bigbacc=0.054
+ bigbinv=0.03
+ bigc=0.054
+ bigsd=0.054
+ binunit=1
+ bvs=11
+ capmod=2
+ cdsc=0.00024
+ cdscb=0
+ cdscd=0
+ cgbo=1e-013
+ cgdl='1.5e-010*nfet_06v0_cgdo'
+ cgdo='1e-010*nfet_06v0_cgdo'
+ cgidl=0.5
+ cgsl='1.5e-010*nfet_06v0_cgso'
+ cgso='1e-010*nfet_06v0_cgso'
+ cigbacc=0.075
+ cigbinv=0.006
+ cigc=0.075
+ cigsd=0.075
+ cit=0
+ cjs=0.00095
+ cjswgs=3.573e-010
+ cjsws=1.33e-010
+ ckappad=0.6
+ ckappas=0.6
+ clc=1e-010
+ cle=0.6
+ delta=0.01
+ diomod=1
+ dlc=5.4e-8
+ dlcig=0
+ dmcg=0
+ dmcgt=0
+ dmdg=0
+ drout=0.4
+ dsub=0.4
+ dvt0=5.72
+ dvt0w=10
+ dvt1=0.299
+ dvt1w=976700
+ dvt2=-0.0793
+ dvt2w=0.15
+ dvtp0=0
+ dvtp1=0
+ dwb=6e-009
+ dwc=0
+ dwg=-6e-010
+ ef=1
+ egidl=0.8
+ eigbinv=1.1
+ em=4.1e+007
+ epsrox=3.9
+ eta0=0
+ etab=-0.43
+ eu=1.67
+ fnoimod=1
+ fprout=0
+ gbmin=1e-012
+ geomod=0
+ igbmod=0
+ igcmod=0
+ ijthsfwd=0.1
+ ijthsrev=0.1
+ jss=6.88e-007
+ jswgs=0
+ jsws=4.88e-013
+ jtsd=0
+ jtss=0
+ jtsswd=0
+ jtsswgd=0
+ jtsswgs=0
+ jtssws=0
+ k1=0.9
+ k2=-0.001
+ k2we=0
+ k3=-1.1369995
+ k3b=0.86
+ keta=-0.021200265
+ kt1=-0.412
+ kt1l=3.5e-008
+ kt2=-0.05
+ ku0=0
+ ku0we=0
+ kvsat=0
+ kvth0=0
+ kvth0we=0
+ la0=0.40143954
+ lags=-0.069000099
+ lambda=0
+ lat=85782.454
+ level=54
+ lint=-3e-008
+ lintnoi=0
+ lketa=0.041400183
+ lku0=0
+ lkvth0=0
+ ll=1.93e-014
+ llc=0
+ lln=1
+ llodku0=0
+ llodvth=0
+ lmax=7e-007
+ lmin=6e-007
+ lodeta0=1
+ lodk2=1
+ lp=1e-008
+ lpclm=0.89088046
+ lpe0=1.63e-007
+ lpeb=0
+ lu0=0.019999754
+ lua=3.7339196e-019
+ lub=1.7399991e-018
+ luc=9.7999741e-011
+ luc1=-1.8816017e-011
+ lute=0.030000412
+ lvsat='24946.5*nfet_06v0_vsat'
+ lw=0
+ lwc=0
+ lwl=0
+ lwlc=0
+ lwn=1
+ minv=0
+ mjs=0.296
+ mjswgs=0.40313
+ mjsws=0.01
+ mobmod=0
+ moin=15
+ ndep=1.7e+017
+ nfactor=0.864
+ ngate=1e+020
+ ngcon=1
+ nigbacc=1
+ nigbinv=3
+ nigc=1
+ njs=1.0541
+ njts=20
+ njtssw=20
+ njtsswg=20
+ noff=1.5
+ noia='nfet_06v0_noia'
+ noib='nfet_06v0_noib'
+ noic='nfet_06v0_noic'
+ nsd=1e+020
+ ntnoi=1
+ ntox=1
+ pags=0.0070909573
+ paramchk=1
+ pat=21832.424
+ pbs=0.606
+ pbswgs=0.861
+ pbsws=0.48
+ pclm=0.0099996572
+ pdiblc1=1.6
+ pdiblc2=0.0022
+ pdiblcb=0
+ pdits=0
+ pditsd=0
+ pditsl=0
+ permod=1
+ phin=0
+ pigcd=1
+ pku0=0
+ pkvth0=0
+ poxedge=1
+ prt=0
+ prwb=0
+ prwg=1
+ pscbe1=4.325e+009
+ pscbe2=8.8e-006
+ pu0=0.0018000207
+ pua=1.4622711e-010
+ pub=-2.3804013e-019
+ puc=-5.6167642e-012
+ pute=-0.020000108
+ pvag=1.75
+ pvsat='6308.7053*nfet_06v0_vsat'
+ rbdb=50
+ rbdbx0=100
+ rbdby0=100
+ rbodymod=0
+ rbpb=50
+ rbpbx0=100
+ rbpbxl=0
+ rbpbxnf=0
+ rbpbxw=0
+ rbpby0=100
+ rbpbyl=0
+ rbpbynf=0
+ rbpbyw=0
+ rbpd=50
+ rbpd0=50
+ rbpdl=0
+ rbpdnf=0
+ rbpdw=0
+ rbps=50
+ rbps0=50
+ rbpsl=0
+ rbpsnf=0
+ rbpsw=0
+ rbsb=50
+ rbsbx0=100
+ rbsby0=100
+ rbsdbxl=0
+ rbsdbxnf=0
+ rbsdbxw=0
+ rbsdbyl=0
+ rbsdbynf=0
+ rbsdbyw=0
+ rdsmod=0
+ rdsw=2175
+ rdswmin=0
+ rdw=100
+ rdwmin=0
+ rgatemod=0
+ rgeomod=0
+ rsh=7
+ rshg=0.1
+ rsw=100
+ rswmin=0
+ saref=1e-006
+ sbref=1e-006
+ scref=1e-006
+ steta0=0
+ stk2=0
+ tcj=0.000825
+ tcjsw=0.0018
+ tcjswg=0.001595
+ tempmod=0
+ tku0=0
+ tnjts=0
+ tnjtssw=0
+ tnjtsswg=0
+ tnoimod=0
+ tnom=25
+ toxe='1.52e-008+nfet_06v0_tox'
+ toxm='1.52e-008+nfet_06v0_tox'
+ toxp='1.6e-008+nfet_06v0_tox'
+ toxref=1.52e-008
+ tpb=0.00146
+ tpbsw=0.00313
+ tpbswg=0.0016588
+ trnqsmod=0
+ tvfbsdoff=0
+ tvoff=0
+ u0=0.052500361
+ ua=6.7999991e-012
+ ua1=1e-009
+ ub=2.8800011e-018
+ ub1=-1e-018
+ uc=7.9400388e-011
+ uc1=-5.5999975e-011
+ ud1=0
+ up=0
+ ute=-1.5000008
+ vbm=-3
+ version=4.5
+ vfbcv=-1
+ vfbsdoff=0
+ voff=-0.08
+ voffcv=0
+ voffl=0
+ vsat='64848.09*nfet_06v0_vsat'
+ vth0='0.67314+nfet_06v0_vth0'
+ vtl=200000
+ vtsd=10
+ vtss=10
+ vtsswd=10
+ vtsswgd=10
+ vtsswgs=10
+ vtssws=10
+ w0=1e-009
+ wags=5.7853969e-008
+ wat=-33999.727
+ web=0
+ wec=0
+ wint=1.55e-008
+ wk3=-0.047531062
+ wku0=0
+ wkvth0=0
+ wl=0
+ wlc=0
+ wln=1
+ wlod=0
+ wlodku0=0
+ wlodvth=0
+ wmax=0.000100001
+ wmin=3e-007
+ wpemod=0
+ wr=1
+ wu0=-2.8167565e-008
+ wua=1.3244868e-016
+ wub=1.8765824e-025
+ wuc=7.9999428e-012
+ wute=0.060000189
+ wvsat='0.14568305*nfet_06v0_vsat'
+ ww=-2.7e-015
+ wwc=0
+ wwl=0
+ wwlc=0
+ wwn=1
+ xgl=0
+ xgw=0
+ xj=1.5e-007
+ xjbvd=1
+ xjbvs=1
+ xl='0+nfet_06v0_xl'
+ xn=3
+ xpart=0
+ xrcrg1=12
+ xrcrg2=1
+ xtis=3
+ xtsd=0.02
+ xtss=0.02
+ xtsswd=0.02
+ xtsswgd=0.02
+ xtsswgs=0.02
+ xtssws=0.02
+ xw='0+nfet_06v0_xw'
.subckt nplus_u_m2 1 2 3 lr=lr wr=wr dtemp=0 r_rsh0=rsh_nplus_u_m r_dw=-5e-8 r_dl=0 r_vc1=0 r_vc2=0 r_tc1=1.36e-3 r_tc2=6.5e-7 r_tnom=25 r_l='lr-2*r_dl' r_w='wr-2*r_dw' r_n='r_l/r_w' r_temp='1+r_tc1*(temper+dtemp-r_tnom)+r_tc2*(temper+dtemp-r_tnom)*(temper+dtemp-r_tnom)'
.model np_junction d
+ cj=0.00096797
+ cjsw=1.5663e-010
+ cta=0.0009438
+ ctp=0.00060474
+ level=3
+ mj=0.32071
+ mjsw=0.1
+ pb=0.70172
+ php=0.8062
+ tlevc=1
+ tpb=0.0018129
+ tphp=5e-005
+ tref=25
d1 3 1 np_junction area='r_w*r_l' pj='2*(r_w+r_l)'
rb 1 2 r='r_temp*r_n*(r_rsh0+r_vc1*abs(v(1,2))/r_n+r_vc2*abs(v(1,2))*abs(v(1,2))/r_n/r_n)'
.ends nplus_u_m2
.subckt pfet_06v0_dss d g s b w=10u l=0.5u nf=1 m=1 par=1 s_sab=0.28u d_sab=2.78u as=0 ad=0 ps=0 pd=0 nrd=0 nrs=0 dtemp=0 sa=0 sb=0 sd=0
.param par_vth=0.01051
.param par_k=0.00517
.param par_l=3e-7
.param par_w=-4e-7
.param par_leff='l-par_l'
.param par_weff='par*(w-par_w)'
.param p_sqrtarea='sqrt((par_leff)*(par_weff))'
.param var_k='0.7071*par_k*1e-06/p_sqrtarea'
.param mis_k='agauss(0,var_k,1)'
.param var_vth='0.7071*par_vth*1e-06/p_sqrtarea'
.param mis_vth='agauss(0,var_vth,1)'
xr1 d d1 b pplus_u_m2 wr='w' lr='(d_sab==0)?1e-15:d_sab'
xr2 s s1 b pplus_u_m2 wr='w' lr='(s_sab==0)?1e-15:s_sab'
m0 d1 g s1 b pfet_06v0 ad=ad as=as delvto='mis_vth*sw_stat_mismatch' l='l' m=m mulu0='1-mis_k*sw_stat_mismatch' nf=nf nrd=nrd nrs=nrs pd=pd ps=ps sa=0 sb=0 sd=0 w='w'
.ends
.model pfet_06v0.0 pmos
+ a0=0.84
+ a1=0
+ a2=1
+ acde=0.7
+ acnqsmod=0
+ agidl=1.1e-15
+ ags=0.059
+ alpha0=9.6e-7
+ alpha1=51.5
+ at=-2.18e4
+ b0=2.625e-8
+ b1=0
+ beta0=50.8
+ bgidl=1.578e5
+ binunit=1
+ bvd=10.5
+ bvs=10.5
+ capmod=2
+ cdsc=2.4e-4
+ cdscb=0
+ cdscd=0
+ cgbo=1e-13
+ cgdl='5.25e-11*pfet_06v0_dcgdo'
+ cgdo='7.71e-11*pfet_06v0_dcgdo'
+ cgsl='5.25e-11*pfet_06v0_dcgso'
+ cgso='7.71e-11*pfet_06v0_dcgso'
+ cit=0
+ cjd=0.000912
+ cjs=0.000912
+ cjswd=1.4649e-010
+ cjswgd=3.3229e-010
+ cjswgs=3.3229e-010
+ cjsws=1.4649e-010
+ ckappad=0.6
+ ckappas=0.6
+ delta=0.01
+ diomod=1
+ dlc=7.4e-9
+ drout=0.56
+ dsub=0.4824
+ dvt0=1
+ dvt0w=0
+ dvt1=1
+ dvt1w=5.3e6
+ dvt2=0
+ dvt2w=-0.032
+ dvtp0=0
+ dvtp1=0.3
+ dwb=-3e-9
+ dwg=-6.6e-9
+ ef=1.1
+ egidl=1.19653e-2
+ epsrox=3.9
+ eta0=0.08
+ etab=-0.09408
+ fnoimod=1
+ fprout=0
+ geomod=1
+ igbmod=0
+ igcmod=0
+ ijthdfwd=0.1
+ ijthdrev=0.1
+ ijthsfwd=0.1
+ ijthsrev=0.1
+ jsd=2.0867e-007
+ jss=2.0867e-007
+ jswd=1.6088e-013
+ jswgd=0
+ jswgs=0
+ jsws=1.6088e-013
+ k1=0.9588
+ k2=8.936e-3
+ k3=-0.75
+ k3b=1.2104
+ keta=-8.6016e-5
+ kt1=-0.3828
+ kt1l=-3.158e-8
+ kt2=-0.09064
+ lambda=0
+ lc=0
+ level=54
+ lint=6.7e-8
+ ll=-5.4e-15
+ lln=1
+ lmax=50.01e-6
+ lmin=0.5e-6
+ lpe0=-4.4e-8
+ lpeb=-5.96e-8
+ lphin=0.1408
+ lua1=-6.554813e-10
+ lub1=1.939773e-19
+ luc=8.691408e-11
+ luc1=-1.067674e-10
+ lute=-0.152467
+ lw=0
+ lwl=-4.76e-21
+ lwn=1
+ minv=0
+ mjd=0.32713
+ mjs=0.32713
+ mjswd=0.056777
+ mjswgd=0.50996
+ mjswgs=0.50996
+ mjsws=0.056777
+ mobmod=0
+ moin=15
+ ndep=1.7e17
+ nfactor=1
+ ngate=3.6e19
+ njd=1
+ njs=1
+ noff=1
+ noia='pfet_06v0_noia'
+ noib='pfet_06v0_noib'
+ noic='pfet_06v0_noic'
+ nsd=6e16
+ pagidl=6.27545e-16
+ paramchk=1
+ pat=-6.1e3
+ pbd=0.76836
+ pbeta0=0.14
+ pbs=0.76836
+ pbswd=0.5
+ pbswgd=1.2295
+ pbswgs=1.2295
+ pbsws=0.5
+ pclm=0.42
+ pdiblc1=0.14
+ pdiblc2=1e-5
+ pdiblcb=0
+ pdits=0.01
+ pditsd=0
+ pditsl=0
+ permod=1
+ petab=-0.012128
+ phin=0
+ pkt1=2.2e-3
+ ppclm=0.071
+ pprwb=-0.052
+ prdsw=-120
+ prt=454
+ prwb=0.569552
+ prwg=0.0432
+ pscbe1=5.088e8
+ pscbe2=1e-8
+ pua1=-3.823641e-10
+ pub1=7.291324e-19
+ puc=-1.501336e-11
+ puc1=1.8536e-11
+ pvag=1.5
+ pvth0='7.6e-3+8.47e-3*pfet_06v0_dvth0'
+ rbodymod=0
+ rdsmod=0
+ rdsw=1.426e3
+ rdswmin=100
+ rsh=7
+ rshg=0.1
+ tcj=0.001
+ tcjsw=0.00071888
+ tcjswg=0.0009411
+ tempmod=0
+ tnoimod=0
+ tnom=25
+ toxe='1.56e-8+pfet_06v0_dtox'
+ tpb=0.0019314
+ tpbsw=0.0017642
+ tpbswg=0.0016588
+ trnqsmod=0
+ u0=0.0151
+ ua=1.78e-9
+ ua1=1.41e-9
+ ub=4.88e-19
+ ub1=-4.31e-18
+ uc=-2.7435e-11
+ uc1=1.147552e-10
+ ute=-1.2
+ version=4.6
+ vfb=-1
+ voff=-0.1284
+ voffcv=0
+ voffl=2.19e-8
+ vsat=8.55e4
+ vth0='-0.8978+pfet_06v0_dvth0'
+ vtl=2e5
+ w0=3.1e-7
+ wbeta0=0.22
+ wint=4.9e-8
+ wketa=2.772e-3
+ wl=0
+ wln=1
+ wmax=100.01e-6
+ wmin=0.3e-6
+ wr=1
+ wrdsw=213.9
+ wua1=-1.2e-10
+ wute=-0.07
+ ww=-1.37e-14
+ wwl=3.04e-22
+ wwn=1
+ xj=1.5e-7
+ xjbvd=1
+ xjbvs=1
+ xl='0+pfet_06v0_dxl'
+ xn=3
+ xpart=1
+ xtid=3
+ xtis=3
+ xw='0+pfet_06v0_dxw'
.subckt pplus_u_m2 1 2 3 lr=lr wr=wr dtemp=0 par=1 r_rsh0=rsh_pplus_u_m r_dw=2.75e-8 r_dl=0 r_vc1=0 r_vc2=0 r_tc1=1.375e-3 r_tc2=1e-6 r_tnom=25 r_l='lr-2*r_dl' r_w='wr-2*r_dw' r_n='r_l/r_w' r_temp='1+r_tc1*(temper+dtemp-r_tnom)+r_tc2*(temper+dtemp-r_tnom)*(temper+dtemp-r_tnom)'
.model pn_junction d
+ cj=0.00094344
+ cjsw=1.5078e-010
+ cta=0.00099187
+ ctp=0.00063483
+ level=3
+ mj=0.32084
+ mjsw=0.05
+ pb=0.69939
+ php=0.8022
+ tlevc=1
+ tpb=0.0016906
+ tphp=0.0058423
+ tref=25
d1 1 3 pn_junction area='r_w*r_l' pj='2*(r_w+r_l)'
rb 1 2 r='r_temp*r_n*(r_rsh0+r_vc1*abs(v(1,2))/r_n+r_vc2*abs(v(1,2))*abs(v(1,2))/r_n/r_n)'
.ends pplus_u_m2
.subckt nfet_06v0_nvt d g s b w=1e-5 l=1.8e-6 nf=1 m=1 as=0 ad=0 ps=0 pd=0 nrd=0 nrs=0 par=1 dtemp=0 sa=0 sb=0 sd=0
m0 d g s b nfet_06v0_nvt ad=ad as=as l=l m=m nf=nf nrd=nrd nrs=nrs pd=pd ps=ps sa=sa sb=sb sd=sd w=w
.ends nfet_06v0_nvt
.model nfet_06v0_nvt.0 nmos
+ a0=0.88
+ a1=0
+ a2=0.47
+ acde=0.3
+ acnqsmod=0
+ agidl=2e-010
+ ags=0.72
+ aigbacc=0.43
+ aigbinv=0.35
+ aigc=0.43
+ aigsd=0.43
+ alpha0=1.36e-008
+ alpha1=1e-005
+ at=80000
+ b0=3.5e-007
+ b1=0
+ beta0=15
+ bgidl=2.3e+009
+ bigbacc=0.054
+ bigbinv=0.03
+ bigc=0.054
+ bigsd=0.054
+ binunit=1
+ bvs=11
+ capmod=2
+ cdsc=0.00024
+ cdscb=0
+ cdscd=0
+ cgbo=1e-013
+ cgdl=1.5e-010
+ cgdo='nfet_06v0_nvt_cgdo'
+ cgidl=0.5
+ cgsl=1.5e-010
+ cgso='nfet_06v0_nvt_cgso'
+ cigbacc=0.075
+ cigbinv=0.006
+ cigc=0.075
+ cigsd=0.075
+ cit=0
+ cjs=0.00095
+ cjswgs=3.573e-010
+ cjsws=1.33e-010
+ ckappad=0.6
+ ckappas=0.6
+ clc=1e-010
+ cle=0.6
+ delta=0.005
+ diomod=1
+ dlc=0
+ dlcig=0
+ dmcg=0
+ dmcgt=0
+ dmdg=0
+ drout=0.16
+ dsub=0.4
+ dvt0=2.2
+ dvt0w=0
+ dvt1=0.53
+ dvt1w=5300000
+ dvt2=-0.032
+ dvt2w=-0.032
+ dvtp0=1e-008
+ dvtp1=0
+ dwb=0
+ dwc=0
+ dwg=0
+ ef=1
+ egidl=0.8
+ eigbinv=1.1
+ em=4.1e+007
+ epsrox=3.9
+ eta0=0.06
+ etab=-0.43
+ eu=1.67
+ fnoimod=1
+ fprout=65
+ gbmin=1e-012
+ geomod=0
+ igbmod=0
+ igcmod=0
+ ijthsfwd=0.1
+ ijthsrev=0.1
+ jss=6.88e-007
+ jswgs=0
+ jsws=4.88e-013
+ jtsd=0
+ jtss=0
+ jtsswd=0
+ jtsswgd=0
+ jtsswgs=0
+ jtssws=0
+ k1=0.165
+ k2=-0.001
+ k2we=0
+ k3=-0.6
+ k3b=-0.6
+ keta=-0.04
+ kt1=-0.412
+ kt1l=3.5e-008
+ kt2=-0.05
+ ku0=0
+ ku0we=0
+ kvsat=0
+ kvth0=0
+ kvth0we=0
+ lambda=0
+ lat=-30000
+ level=54
+ lint=1e-007
+ lintnoi=0
+ lku0=0
+ lkvth0=0
+ ll=0
+ llc=0
+ lln=1
+ llodku0=0
+ llodvth=0
+ lmax=50.01e-6
+ lmin=1.8e-6
+ lnfactor=0.45
+ lodeta0=1
+ lodk2=1
+ lp=1e-008
+ lpe0=1e-007
+ lpeb=0
+ lu0=0.042
+ lub=3.65e-018
+ lute=-0.26
+ lvth0=-0.088
+ lw=0
+ lwc=0
+ lwl=0
+ lwlc=0
+ lwn=1
+ minv=-0.5
+ mjs=0.296
+ mjswgs=0.40313
+ mjsws=0.01
+ mobmod=0
+ moin=15
+ ndep=1.7e+017
+ nfactor=0.40241
+ ngate=1e+020
+ ngcon=1
+ nigbacc=1
+ nigbinv=3
+ nigc=1
+ njs=1.0541
+ njts=20
+ njtssw=20
+ njtsswg=20
+ noff=1.5
+ noia='nfet_06v0_nvt_noia'
+ noib='nfet_06v0_nvt_noib'
+ noic='nfet_06v0_nvt_noic'
+ nsd=1e+020
+ ntnoi=1
+ ntox=1
+ paramchk=1
+ pat=-10000
+ pbs=0.606
+ pbswgs=0.861
+ pbsws=0.48
+ pclm=3
+ pdiblc1=1.41
+ pdiblc2=1e-005
+ pdiblcb=0
+ pdits=0
+ pditsd=0
+ pditsl=0
+ permod=1
+ phin=0.5
+ pigcd=1
+ pku0=0
+ pkvth0=0
+ poxedge=1
+ prt=0
+ prwb=0
+ prwg=1
+ pscbe1=5e+009
+ pscbe2=5e-006
+ pvag=1
+ pvsat=23500
+ rbdb=50
+ rbdbx0=100
+ rbdby0=100
+ rbodymod=0
+ rbpb=50
+ rbpbx0=100
+ rbpbxl=0
+ rbpbxnf=0
+ rbpbxw=0
+ rbpby0=100
+ rbpbyl=0
+ rbpbynf=0
+ rbpbyw=0
+ rbpd=50
+ rbpd0=50
+ rbpdl=0
+ rbpdnf=0
+ rbpdw=0
+ rbps=50
+ rbps0=50
+ rbpsl=0
+ rbpsnf=0
+ rbpsw=0
+ rbsb=50
+ rbsbx0=100
+ rbsby0=100
+ rbsdbxl=0
+ rbsdbxnf=0
+ rbsdbxw=0
+ rbsdbyl=0
+ rbsdbynf=0
+ rbsdbyw=0
+ rdsmod=0
+ rdsw=3480
+ rdswmin=0
+ rdw=100
+ rdwmin=0
+ rgatemod=0
+ rgeomod=0
+ rsh=7
+ rshg=0.1
+ rsw=100
+ rswmin=0
+ saref=1e-006
+ sbref=1e-006
+ scref=1e-006
+ steta0=0
+ stk2=0
+ tcj=0.000825
+ tcjsw=0.0018
+ tcjswg=0.001595
+ tempmod=0
+ tku0=0
+ tnjts=0
+ tnjtssw=0
+ tnjtsswg=0
+ tnoimod=0
+ tnom=25
+ toxe='nfet_06v0_nvt_tox'
+ toxm=1.52e-008
+ toxp=1.6e-008
+ toxref=1.52e-008
+ tpb=0.00146
+ tpbsw=0.00313
+ tpbswg=0.0016588
+ trnqsmod=0
+ tvfbsdoff=0
+ tvoff=0
+ u0='nfet_06v0_nvt_u0'
+ ua=2.278e-009
+ ua1=1e-009
+ ub=3.97e-019
+ ub1=-1e-018
+ uc=2.625e-012
+ uc1=-5.6e-011
+ ud1=0
+ up=0
+ ute=-1.5
+ vbm=-3
+ version=4.6
+ vfbcv=-1
+ vfbsdoff=0
+ voff=-0.06
+ voffcv=0
+ voffl=0
+ vsat=106700
+ vth0='nfet_06v0_nvt_vth0'
+ vtl=200000
+ vtsd=10
+ vtss=10
+ vtsswd=10
+ vtsswgd=10
+ vtsswgs=10
+ vtssws=10
+ w0=1e-010
+ web=0
+ wec=0
+ wint=1e-009
+ wku0=0
+ wkvth0=0
+ wl=0
+ wlc=0
+ wln=1
+ wlod=0
+ wlodku0=0
+ wlodvth=0
+ wmax=100.01e-6
+ wmin=0.8e-6
+ wpemod=0
+ wr=1
+ ww=0
+ wwc=0
+ wwl=0
+ wwlc=0
+ wwn=1
+ xgl=0
+ xgw=0
+ xj=1.5e-007
+ xjbvd=1
+ xjbvs=1
+ xl='nfet_06v0_nvt_xl'
+ xn=3
+ xpart=0
+ xrcrg1=12
+ xrcrg2=1
+ xtis=3
+ xtsd=0.02
+ xtss=0.02
+ xtsswd=0.02
+ xtsswgd=0.02
+ xtsswgs=0.02
+ xtssws=0.02
+ xw='nfet_06v0_nvt_xw'
.param nfet_03v3_noia='(fnoicor==0)*3.2e+041+(fnoicor==1)*3.5e+042'
.param nfet_03v3_noib='(fnoicor==0)*1.2e+020+(fnoicor==1)*1.2e+020'
.param nfet_03v3_noic='(fnoicor==0)*6.0e+008+(fnoicor==1)*6.0e+008'
.param pfet_03v3_noia='(fnoicor==0)*3.2e+041+(fnoicor==1)*4.0e+042'
.param pfet_03v3_noib='(fnoicor==0)*1.8e+020+(fnoicor==1)*1.8e+020'
.param pfet_03v3_noic='(fnoicor==0)*3.0e+009+(fnoicor==1)*6.0e+009'
.param nfet_06v0_noia='(fnoicor==0)*1.998e+041+(fnoicor==1)*8e+041'
.param nfet_06v0_noib='(fnoicor==0)*1e+025+(fnoicor==1)*4e+025'
.param nfet_06v0_noic='(fnoicor==0)*5e+008+(fnoicor==1)*2e+009'
.param pfet_06v0_noia='(fnoicor==0)*6e+040+(fnoicor==1)*2e+043'
.param pfet_06v0_noib='(fnoicor==0)*1.5945e+025+(fnoicor==1)*1.5945e+025'
.param pfet_06v0_noic='(fnoicor==0)*1.0499e+009+(fnoicor==1)*1.0499e+009'
.param nfet_06v0_nvt_noia='(fnoicor==0)*5.5e+040+(fnoicor==1)*1e+041'
.param nfet_06v0_nvt_noib='(fnoicor==0)*2.5e+025+(fnoicor==1)*9.5e+025'
.param nfet_06v0_nvt_noic='(fnoicor==0)*1e+007+(fnoicor==1)*2e+007'
.subckt nfet_03v3 d g s b w=1e-5 l=2.8e-7 nf=1 m=1 as=0 ad=0 ps=0 pd=0 nrd=0 nrs=0 par=1 dtemp=0 sa=0 sb=0 sd=0
.param par_vth=0.007148
.param par_k=0.007008
.param par_l=1.5e-7
.param par_w=-1e-7
.param par_leff='l-par_l'
.param par_weff='par*(w-par_w)'
.param p_sqrtarea='sqrt((par_leff)*(par_weff))'
.param var_k='0.7071*par_k*1e-06/p_sqrtarea'
.param mis_k='agauss(0,var_k,1)'
.param var_vth='0.7071*par_vth*1e-06/p_sqrtarea'
.param mis_vth='agauss(0,var_vth,1)'
m0 d g s b nfet_03v3 ad=ad as=as delvto='mis_vth*sw_stat_mismatch' l=l m=m mulu0='1-mis_k*sw_stat_mismatch' nf=nf nrd=nrd nrs=nrs pd=pd ps=ps sa=sa sb=sb sd=sd w=w
.ends nfet_03v3
.subckt pfet_03v3 d g s b w=1e-5 l=2.8e-7 nf=1 m=1 as=0 ad=0 ps=0 pd=0 nrd=0 nrs=0 par=1 dtemp=0 sa=0 sb=0 sd=0
.param par_vth=0.00666
.param par_k=0.002833
.param par_l=1.5e-7
.param par_w=-1e-7
.param par_leff='l-par_l'
.param par_weff='par*(w-par_w)'
.param p_sqrtarea='sqrt((par_leff)*(par_weff))'
.param var_k='0.7071*par_k*1e-06/p_sqrtarea'
.param mis_k='agauss(0,var_k,1)'
.param var_vth='0.7071*par_vth*1e-06/p_sqrtarea'
.param mis_vth='agauss(0,var_vth,1)'
m0 d g s b pfet_03v3 ad=ad as=as delvto='mis_vth*sw_stat_mismatch' l=l m=m mulu0='1-mis_k*sw_stat_mismatch' nf=nf nrd=nrd nrs=nrs pd=pd ps=ps sa=sa sb=sb sd=sd w=w
.ends pfet_03v3
.subckt nfet_05v0 d g s b w=1e-6 l=6e-7 nf=1 m=1 as=0 ad=0 ps=0 pd=0 nrd=0 nrs=0 par=1 dtemp=0 sa=0 sb=0 sd=0
.param par_vth=0.01155
.param par_k=0.0000
.param par_l=4e-7
.param par_w=-5e-7
.param par_leff='l-par_l'
.param par_weff='par*(w-par_w)'
.param p_sqrtarea='sqrt((par_leff)*(par_weff))'
.param var_k='0.7071*par_k*1e-06/p_sqrtarea'
.param mis_k=agauss(0,var_k,1)
.param var_vth='0.7071*par_vth*1e-06/p_sqrtarea'
.param mis_vth=agauss(0,var_vth,1)
m0 d g s b nfet_06v0 ad=ad as=as delvto='mis_vth*sw_stat_mismatch' l=l m=m mulu0='1-mis_k*sw_stat_mismatch' nf=nf nrd=nrd nrs=nrs pd=pd ps=ps sa=sa sb=sb sd=sd w=w
.ends nfet_05v0
.subckt nfet_06v0 d g s b w=1e-5 l=7e-7 nf=1 m=1 as=0 ad=0 ps=0 pd=0 nrd=0 nrs=0 par=1 dtemp=0 sa=0 sb=0 sd=0
.param par_vth=0.01155
.param par_k=0.0000
.param par_l=4e-7
.param par_w=-5e-7
.param par_leff='l-par_l'
.param par_weff='par*(w-par_w)'
.param p_sqrtarea='sqrt((par_leff)*(par_weff))'
.param var_k='0.7071*par_k*1e-06/p_sqrtarea'
.param mis_k='agauss(0,var_k,1)'
.param var_vth='0.7071*par_vth*1e-06/p_sqrtarea'
.param mis_vth='agauss(0,var_vth,1)'
m0 d g s b nfet_06v0 ad=ad as=as delvto='mis_vth*sw_stat_mismatch' l=l m=m mulu0='1-mis_k*sw_stat_mismatch' nf=nf nrd=nrd nrs=nrs pd=pd ps=ps sa=sa sb=sb sd=sd w=w
.ends nfet_06v0
.subckt pfet_05v0 d g s b w=1e-5 l=5e-7 nf=1 m=1 as=0 ad=0 ps=0 pd=0 nrd=0 nrs=0 par=1 dtemp=0 sa=0 sb=0 sd=0
.param par_vth=0.01051
.param par_k=0.00517
.param par_l=3e-7
.param par_w=-4e-7
.param par_leff='l-par_l'
.param par_weff='par*(w-par_w)'
.param p_sqrtarea='sqrt((par_leff)*(par_weff))'
.param var_k='0.7071*par_k*1e-06/p_sqrtarea'
.param mis_k=agauss(0,var_k,1)
.param var_vth='0.7071*par_vth*1e-06/p_sqrtarea'
.param mis_vth=agauss(0,var_vth,1)
m0 d g s b pfet_06v0 ad=ad as=as delvto='mis_vth*sw_stat_mismatch' l=l m=m mulu0='1-mis_k*sw_stat_mismatch' nf=nf nrd=nrd nrs=nrs pd=pd ps=ps sa=sa sb=sb sd=sd w=w
.ends pfet_05v0
.subckt pfet_06v0 d g s b w=1e-5 l=5.5e-7 nf=1 m=1 as=0 ad=0 ps=0 pd=0 nrd=0 nrs=0 par=1 dtemp=0 sa=0 sb=0 sd=0
.param par_vth=0.01051
.param par_k=0.00517
.param par_l=3e-7
.param par_w=-4e-7
.param par_leff='l-par_l'
.param par_weff='par*(w-par_w)'
.param p_sqrtarea='sqrt((par_leff)*(par_weff))'
.param var_k='0.7071*par_k*1e-06/p_sqrtarea'
.param mis_k='agauss(0,var_k,1)'
.param var_vth='0.7071*par_vth*1e-06/p_sqrtarea'
.param mis_vth='agauss(0,var_vth,1)'
m0 d g s b pfet_06v0 ad=ad as=as delvto='mis_vth*sw_stat_mismatch' l=l m=m mulu0='1-mis_k*sw_stat_mismatch' nf=nf nrd=nrd nrs=nrs pd=pd ps=ps sa=sa sb=sb sd=sd w=w
.ends pfet_06v0
